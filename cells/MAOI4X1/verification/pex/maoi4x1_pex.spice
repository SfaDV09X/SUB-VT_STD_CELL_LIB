* NGSPICE file created from maoi4x1.ext - technology: sky130A

.subckt maoi4x1 A B C D Y VDD GND
X0 xn1/S3.t0 xpib/D xn1/D2.t1 GND sky130_fd_pr__nfet_01v8 ad=0.1386 pd=1.17 as=0.1386 ps=1.17 w=0.84 l=0.15
X1 xn1/a_255_n84.t0 xpib/D xn1/S5.t0 GND sky130_fd_pr__nfet_01v8 ad=0.2604 pd=2.3 as=0.1386 ps=1.17 w=0.84 l=0.15
X2 xn1/S5.t1 xpib/D xn1/D4.t1 GND sky130_fd_pr__nfet_01v8 ad=0.1386 pd=1.17 as=0.1386 ps=1.17 w=0.84 l=0.15
X3 xn1/S1.t0 xpib/D xn1/D0.t0 GND sky130_fd_pr__nfet_01v8 ad=0.1386 pd=1.17 as=0.2604 ps=2.3 w=0.84 l=0.15
X4 xn1/D2.t0 xpib/D xn1/S1.t1 GND sky130_fd_pr__nfet_01v8 ad=0.1386 pd=1.17 as=0.1386 ps=1.17 w=0.84 l=0.15
X5 xn1/D4.t0 xpib/D xn1/S3.t1 GND sky130_fd_pr__nfet_01v8 ad=0.1386 pd=1.17 as=0.1386 ps=1.17 w=0.84 l=0.15
X6 xn2/S3.t0 xpia/D xn2/D2.t1 GND sky130_fd_pr__nfet_01v8 ad=0 pd=0 as=0 ps=0 w=0.84 l=0.15
X7 xn2/a_255_n84.t0 xpia/D xn2/S5.t0 GND sky130_fd_pr__nfet_01v8 ad=0 pd=0 as=0 ps=0 w=0.84 l=0.15
X8 xn2/S5.t1 xpia/D xn2/D4.t1 GND sky130_fd_pr__nfet_01v8 ad=0 pd=0 as=0 ps=0 w=0.84 l=0.15
X9 xn2/S1.t0 xpia/D xn2/D0.t0 GND sky130_fd_pr__nfet_01v8 ad=0 pd=0 as=0 ps=0 w=0.84 l=0.15
X10 xn2/D2.t0 xpia/D xn2/S1.t1 GND sky130_fd_pr__nfet_01v8 ad=0 pd=0 as=0 ps=0 w=0.84 l=0.15
X11 xn2/D4.t0 xpia/D xn2/S3.t1 GND sky130_fd_pr__nfet_01v8 ad=0 pd=0 as=0 ps=0 w=0.84 l=0.15
X12 xn3/S3.t0 D xn3/D2.t1 GND sky130_fd_pr__nfet_01v8 ad=0 pd=0 as=0 ps=0 w=0.84 l=0.15
X13 xn3/a_255_n84.t0 D xn3/S5.t0 GND sky130_fd_pr__nfet_01v8 ad=0 pd=0 as=0 ps=0 w=0.84 l=0.15
X14 xn3/S5.t1 D xn3/D4.t1 GND sky130_fd_pr__nfet_01v8 ad=0 pd=0 as=0 ps=0 w=0.84 l=0.15
X15 xn3/S1.t0 D xn3/D0.t0 GND sky130_fd_pr__nfet_01v8 ad=0 pd=0 as=0 ps=0 w=0.84 l=0.15
X16 xn3/D2.t0 D xn3/S1.t1 GND sky130_fd_pr__nfet_01v8 ad=0 pd=0 as=0 ps=0 w=0.84 l=0.15
X17 xn3/D4.t0 D xn3/S3.t1 GND sky130_fd_pr__nfet_01v8 ad=0 pd=0 as=0 ps=0 w=0.84 l=0.15
X18 xn4/S3.t0 C xn4/D2.t1 GND sky130_fd_pr__nfet_01v8 ad=0 pd=0 as=0 ps=0 w=0.84 l=0.15
X19 xn4/a_255_n84.t0 C xn4/S5.t0 GND sky130_fd_pr__nfet_01v8 ad=0 pd=0 as=0 ps=0 w=0.84 l=0.15
X20 xn4/S5.t1 C xn4/D4.t1 GND sky130_fd_pr__nfet_01v8 ad=0 pd=0 as=0 ps=0 w=0.84 l=0.15
X21 xn4/S1.t0 C xn4/D0.t0 GND sky130_fd_pr__nfet_01v8 ad=0 pd=0 as=0 ps=0 w=0.84 l=0.15
X22 xn4/D2.t0 C xn4/S1.t1 GND sky130_fd_pr__nfet_01v8 ad=0 pd=0 as=0 ps=0 w=0.84 l=0.15
X23 xn4/D4.t0 C xn4/S3.t1 GND sky130_fd_pr__nfet_01v8 ad=0 pd=0 as=0 ps=0 w=0.84 l=0.15
X24 xp5/S.t0 xpia/D xp5/D.t0 VDD sky130_fd_pr__pfet_01v8 ad=0.2436 pd=2.26 as=0.2436 ps=2.26 w=0.84 l=0.15
X25 xp6/S.t0 C xp6/D.t0 VDD sky130_fd_pr__pfet_01v8 ad=0 pd=0 as=0 ps=0 w=0.84 l=0.15
X26 xp7/S.t0 xpib/D xp7/D.t0 VDD sky130_fd_pr__pfet_01v8 ad=0 pd=0 as=0 ps=0 w=0.84 l=0.15
X27 xp8/S.t0 D xp8/D.t0 VDD sky130_fd_pr__pfet_01v8 ad=0 pd=0 as=0 ps=0 w=0.84 l=0.15
X28 xpia/S.t0 A xpia/D.t0 VDD sky130_fd_pr__pfet_01v8 ad=0.1218 pd=1.42 as=0.1218 ps=1.42 w=0.42 l=0.15
X29 xpib/S.t0 B xpib/D.t0 VDD sky130_fd_pr__pfet_01v8 ad=0 pd=0 as=0 ps=0 w=0.42 l=0.15
X30 xnia/D2.t0 A xnia/S1.t0 GND sky130_fd_pr__nfet_01v8 ad=0.1386 pd=1.17 as=0.1386 ps=1.17 w=0.84 l=0.15
X31 xnia/S1.t1 A xnia/D0.t0 GND sky130_fd_pr__nfet_01v8 ad=0.1386 pd=1.17 as=0.2604 ps=2.3 w=0.84 l=0.15
X32 xnia/S2.t0 A xnia/D2.t1 GND sky130_fd_pr__nfet_01v8 ad=0.2604 pd=2.3 as=0.1386 ps=1.17 w=0.84 l=0.15
X33 xnib/D2.t0 B xnib/S1.t0 GND sky130_fd_pr__nfet_01v8 ad=0 pd=0 as=0 ps=0 w=0.84 l=0.15
X34 xnib/S1.t1 B xnib/D0.t0 GND sky130_fd_pr__nfet_01v8 ad=0 pd=0 as=0 ps=0 w=0.84 l=0.15
X35 xnib/S2.t0 B xnib/D2.t1 GND sky130_fd_pr__nfet_01v8 ad=0 pd=0 as=0 ps=0 w=0.84 l=0.15
C0 B D 0
C1 Y xpia/D 0.29778f
C2 Y B 0.00771f
C3 xpia/D B 0
C4 xp8/D C 0.04058f
C5 xp8/D VDD 1.20844f
C6 VDD C 0.25646f
C7 xp8/D xpib/D 0.23339f
C8 C xpib/D 0.00809f
C9 VDD xpib/D 0.79761f
C10 A xp8/D 0
C11 xp8/D D 0.03311f
C12 C D 0.01879f
C13 A VDD 0.18976f
C14 VDD D 0.255f
C15 xp8/D Y 1.31567f
C16 Y C 0.19222f
C17 Y VDD 1.24818f
C18 xp8/D xpia/D 0.02839f
C19 VDD xpia/D 0.64819f
C20 A xpib/D 0
C21 xpib/D D 0
C22 xp8/D B 0.01272f
C23 C B 0.01735f
C24 VDD B 0.19908f
C25 Y xpib/D 0.18558f
C26 xpia/D xpib/D 0.02292f
C27 B xpib/D 0.16929f
C28 A Y 0.00144f
C29 Y D 0.03473f
C30 A xpia/D 0.16978f
R0 GND xn1/S5.t0 23.5719
R1 GND xn1/S5.t1 23.5719
R2 GND xn1/S3.t1 23.5719
R3 GND xn1/S3.t0 23.5719
R4 GND xn1/S1.t1 23.5719
R5 GND xn1/S1.t0 23.5719
R6 Y xn2/S5.t0 23.5719
R7 Y xn2/S5.t1 23.5719
R8 Y xn2/S3.t1 23.5719
R9 Y xn2/S3.t0 23.5719
R10 Y xn2/S1.t1 23.5719
R11 Y xn2/S1.t0 23.5719
R12 GND xn3/S5.t0 23.5719
R13 GND xn3/S5.t1 23.5719
R14 GND xn3/S3.t1 23.5719
R15 GND xn3/S3.t0 23.5719
R16 GND xn3/S1.t1 23.5719
R17 GND xn3/S1.t0 23.5719
R18 Y xn4/S5.t0 23.5719
R19 Y xn4/S5.t1 23.5719
R20 Y xn4/S3.t1 23.5719
R21 Y xn4/S3.t0 23.5719
R22 Y xn4/S1.t1 23.5719
R23 Y xn4/S1.t0 23.5719
R24 xp8/D xp5/S.t0 34.0065
R25 VDD xp5/D.t0 34.0065
R26 xp8/D xp6/S.t0 34.0065
R27 Y xp6/D.t0 34.0065
R28 VDD xp7/S.t0 34.0065
R29 xp8/D xp7/D.t0 34.0065
R30 Y xp8/S.t0 34.0065
R31 xp8/D xp8/D.t0 34.0065
R32 VDD xpia/S.t0 68.0124
R33 xpia/D xpia/D.t0 68.0124
R34 VDD xpib/S.t0 68.0124
R35 xpib/D xpib/D.t0 68.0124
R36 xpia/D xnia/S2.t0 23.5719
R37 GND xnia/D2.t1 23.5719
R38 GND xnia/D2.t0 23.5719
R39 xpia/D xnia/S1.t0 23.5719
R40 xpia/D xnia/S1.t1 23.5719
R41 GND xnia/D0.t0 23.5719
R42 xpib/D xnib/S2.t0 23.5719
R43 GND xnib/D2.t1 23.5719
R44 GND xnib/D2.t0 23.5719
R45 xpib/D xnib/S1.t0 23.5719
R46 xpib/D xnib/S1.t1 23.5719
R47 GND xnib/D0.t0 23.5719
C31 B GND 0.67354f
C32 xnib/D0.t0 GND 0.0163f ; **FLOATING
C33 xnib/S1.t0 GND 0.03173f ; **FLOATING
C34 xnib/S1.t1 GND 0.03173f ; **FLOATING
C35 xnib/D2.t1 GND 0.03173f ; **FLOATING
C36 xnib/D2.t0 GND 0.03173f ; **FLOATING
C37 xnib/S2.t0 GND 0.0163f ; **FLOATING
C38 A GND 0.66446f
C39 xnia/D0.t0 GND 0.0163f ; **FLOATING
C40 xnia/S1.t0 GND 0.03173f ; **FLOATING
C41 xnia/S1.t1 GND 0.03173f ; **FLOATING
C42 xnia/D2.t1 GND 0.03173f ; **FLOATING
C43 xnia/D2.t0 GND 0.03173f ; **FLOATING
C44 xnia/S2.t0 GND 0.0163f ; **FLOATING
C45 xpib/D.t0 GND 0.00883f ; **FLOATING
C46 xpib/S.t0 GND 0.00883f ; **FLOATING
C47 xpia/D.t0 GND 0.00883f ; **FLOATING
C48 xpia/S.t0 GND 0.00883f ; **FLOATING
C49 xp8/D.t0 GND 0.01719f ; **FLOATING
C50 xp8/S.t0 GND 0.01719f ; **FLOATING
C51 xp7/D.t0 GND 0.01719f ; **FLOATING
C52 xp7/S.t0 GND 0.01719f ; **FLOATING
C53 xp6/D.t0 GND 0.01719f ; **FLOATING
C54 xp6/S.t0 GND 0.01719f ; **FLOATING
C55 xp8/D GND 1.49935f
C56 VDD GND 12.2745f
C57 xp5/D.t0 GND 0.01719f ; **FLOATING
C58 xp5/S.t0 GND 0.01719f ; **FLOATING
C59 C GND 0.93568f
C60 xn4/a_255_n84.t0 GND 0.14192f ; **FLOATING
C61 xn4/D0.t0 GND 0.0163f ; **FLOATING
C62 xn4/S1.t1 GND 0.03173f ; **FLOATING
C63 xn4/S1.t0 GND 0.03173f ; **FLOATING
C64 xn4/D2.t1 GND 0.03173f ; **FLOATING
C65 xn4/D2.t0 GND 0.03173f ; **FLOATING
C66 xn4/S3.t1 GND 0.03173f ; **FLOATING
C67 xn4/S3.t0 GND 0.03173f ; **FLOATING
C68 xn4/D4.t1 GND 0.03173f ; **FLOATING
C69 xn4/D4.t0 GND 0.03173f ; **FLOATING
C70 xn4/S5.t0 GND 0.03173f ; **FLOATING
C71 xn4/S5.t1 GND 0.03173f ; **FLOATING
C72 D GND 0.97219f
C73 xn3/a_255_n84.t0 GND 0.14192f ; **FLOATING
C74 xn3/D0.t0 GND 0.0163f ; **FLOATING
C75 xn3/S1.t1 GND 0.03173f ; **FLOATING
C76 xn3/S1.t0 GND 0.03173f ; **FLOATING
C77 xn3/D2.t1 GND 0.03173f ; **FLOATING
C78 xn3/D2.t0 GND 0.03173f ; **FLOATING
C79 xn3/S3.t1 GND 0.03173f ; **FLOATING
C80 xn3/S3.t0 GND 0.03173f ; **FLOATING
C81 xn3/D4.t1 GND 0.03173f ; **FLOATING
C82 xn3/D4.t0 GND 0.03173f ; **FLOATING
C83 xn3/S5.t0 GND 0.03173f ; **FLOATING
C84 xn3/S5.t1 GND 0.03173f ; **FLOATING
C85 Y GND 5.78368f
C86 xpia/D GND 1.66252f
C87 xn2/a_255_n84.t0 GND 0.14192f ; **FLOATING
C88 xn2/D0.t0 GND 0.0163f ; **FLOATING
C89 xn2/S1.t1 GND 0.03173f ; **FLOATING
C90 xn2/S1.t0 GND 0.03173f ; **FLOATING
C91 xn2/D2.t1 GND 0.03173f ; **FLOATING
C92 xn2/D2.t0 GND 0.03173f ; **FLOATING
C93 xn2/S3.t1 GND 0.03173f ; **FLOATING
C94 xn2/S3.t0 GND 0.03173f ; **FLOATING
C95 xn2/D4.t1 GND 0.03173f ; **FLOATING
C96 xn2/D4.t0 GND 0.03173f ; **FLOATING
C97 xn2/S5.t0 GND 0.03173f ; **FLOATING
C98 xn2/S5.t1 GND 0.03173f ; **FLOATING
C99 xpib/D GND 1.63258f
C100 xn1/a_255_n84.t0 GND 0.14192f ; **FLOATING
C101 xn1/D0.t0 GND 0.0163f ; **FLOATING
C102 xn1/S1.t1 GND 0.03173f ; **FLOATING
C103 xn1/S1.t0 GND 0.03173f ; **FLOATING
C104 xn1/D2.t1 GND 0.03173f ; **FLOATING
C105 xn1/D2.t0 GND 0.03173f ; **FLOATING
C106 xn1/S3.t1 GND 0.03173f ; **FLOATING
C107 xn1/S3.t0 GND 0.03173f ; **FLOATING
C108 xn1/D4.t1 GND 0.03173f ; **FLOATING
C109 xn1/D4.t0 GND 0.03173f ; **FLOATING
C110 xn1/S5.t0 GND 0.03173f ; **FLOATING
C111 xn1/S5.t1 GND 0.03173f ; **FLOATING
.ends
