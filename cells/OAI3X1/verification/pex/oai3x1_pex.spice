* NGSPICE file created from oai3x1.ext - technology: sky130A

.subckt oai3x1 A B C Y VDD GND
X0 xp3/S.t0 C xp3/D.t0 VDD sky130_fd_pr__pfet_01v8 ad=0.1218 pd=1.42 as=0.1218 ps=1.42 w=0.42 l=0.15
X1 xn4/S3.t0 A xn4/D2.t0 GND sky130_fd_pr__nfet_01v8 ad=0.1386 pd=1.17 as=0.1386 ps=1.17 w=0.84 l=0.15
X2 xn4/a_255_n84.t0 A xn4/S5.t0 GND sky130_fd_pr__nfet_01v8 ad=0.2604 pd=2.3 as=0.1386 ps=1.17 w=0.84 l=0.15
X3 xn4/S5.t1 A xn4/D4.t1 GND sky130_fd_pr__nfet_01v8 ad=0.1386 pd=1.17 as=0.1386 ps=1.17 w=0.84 l=0.15
X4 xn4/S1.t1 A xn4/D0.t0 GND sky130_fd_pr__nfet_01v8 ad=0.1386 pd=1.17 as=0.2604 ps=2.3 w=0.84 l=0.15
X5 xn4/D2.t1 A xn4/S1.t0 GND sky130_fd_pr__nfet_01v8 ad=0.1386 pd=1.17 as=0.1386 ps=1.17 w=0.84 l=0.15
X6 xn4/D4.t0 A xn4/S3.t1 GND sky130_fd_pr__nfet_01v8 ad=0.1386 pd=1.17 as=0.1386 ps=1.17 w=0.84 l=0.15
X7 xn5/S3.t0 B xn5/D2.t0 GND sky130_fd_pr__nfet_01v8 ad=0 pd=0 as=0 ps=0 w=0.84 l=0.15
X8 xn5/a_255_n84.t0 B xn5/S5.t0 GND sky130_fd_pr__nfet_01v8 ad=0 pd=0 as=0 ps=0 w=0.84 l=0.15
X9 xn5/S5.t1 B xn5/D4.t1 GND sky130_fd_pr__nfet_01v8 ad=0 pd=0 as=0 ps=0 w=0.84 l=0.15
X10 xn5/S1.t1 B xn5/D0.t0 GND sky130_fd_pr__nfet_01v8 ad=0 pd=0 as=0 ps=0 w=0.84 l=0.15
X11 xn5/D2.t1 B xn5/S1.t0 GND sky130_fd_pr__nfet_01v8 ad=0 pd=0 as=0 ps=0 w=0.84 l=0.15
X12 xn5/D4.t0 B xn5/S3.t1 GND sky130_fd_pr__nfet_01v8 ad=0 pd=0 as=0 ps=0 w=0.84 l=0.15
X13 xn6/S3.t0 C xn6/D2.t0 GND sky130_fd_pr__nfet_01v8 ad=0 pd=0 as=0 ps=0 w=0.84 l=0.15
X14 xn6/a_255_n84.t0 C xn6/S5.t0 GND sky130_fd_pr__nfet_01v8 ad=0 pd=0 as=0 ps=0 w=0.84 l=0.15
X15 xn6/S5.t1 C xn6/D4.t1 GND sky130_fd_pr__nfet_01v8 ad=0 pd=0 as=0 ps=0 w=0.84 l=0.15
X16 xn6/S1.t1 C xn6/D0.t0 GND sky130_fd_pr__nfet_01v8 ad=0 pd=0 as=0 ps=0 w=0.84 l=0.15
X17 xn6/D2.t1 C xn6/S1.t0 GND sky130_fd_pr__nfet_01v8 ad=0 pd=0 as=0 ps=0 w=0.84 l=0.15
X18 xn6/D4.t0 C xn6/S3.t1 GND sky130_fd_pr__nfet_01v8 ad=0 pd=0 as=0 ps=0 w=0.84 l=0.15
X19 xp1/S.t0 B xp1/D.t0 VDD sky130_fd_pr__pfet_01v8 ad=0.2436 pd=2.26 as=0.2436 ps=2.26 w=0.84 l=0.15
X20 xp2/S.t0 A xp2/D.t0 VDD sky130_fd_pr__pfet_01v8 ad=0 pd=0 as=0 ps=0 w=0.84 l=0.15
C0 xp2/S A 0.01903f
C1 VDD Y 0.57336f
C2 B xp2/S 0.01766f
C3 C B 0.01819f
C4 Y A 0.1666f
C5 VDD A 0.26484f
C6 C xp2/S 0
C7 B Y 0.19561f
C8 VDD B 0.25771f
C9 Y xp2/S 0.2462f
C10 C Y 0.03598f
C11 VDD xp2/S 0.53681f
C12 C VDD 0.29131f
C13 B A 0.01879f
R0 VDD xp3/S.t0 68.0124
R1 Y xp3/D.t0 68.0124
R2 Y xn4/S5.t0 23.5719
R3 Y xn4/S5.t1 23.5719
R4 Y xn4/S3.t1 23.5719
R5 Y xn4/S3.t0 23.5719
R6 Y xn4/S1.t0 23.5719
R7 Y xn4/S1.t1 23.5719
R8 Y xn5/S5.t0 23.5719
R9 Y xn5/S5.t1 23.5719
R10 Y xn5/S3.t1 23.5719
R11 Y xn5/S3.t0 23.5719
R12 Y xn5/S1.t0 23.5719
R13 Y xn5/S1.t1 23.5719
R14 GND xn6/S5.t0 23.5719
R15 GND xn6/S5.t1 23.5719
R16 GND xn6/S3.t1 23.5719
R17 GND xn6/S3.t0 23.5719
R18 GND xn6/S1.t0 23.5719
R19 GND xn6/S1.t1 23.5719
R20 Y xp1/S.t0 34.0065
R21 xp2/S xp1/D.t0 34.0065
R22 xp2/S xp2/S.t0 34.0065
R23 VDD xp2/D.t0 34.0065
C14 xp2/S GND 0.29395f
C15 A GND 0.92267f
C16 xp2/D.t0 GND 0.01719f ; **FLOATING
C17 xp2/S.t0 GND 0.01719f ; **FLOATING
C18 B GND 0.92642f
C19 xp1/D.t0 GND 0.01719f ; **FLOATING
C20 xp1/S.t0 GND 0.01719f ; **FLOATING
C21 xn6/a_255_n84.t0 GND 0.14192f ; **FLOATING
C22 xn6/D0.t0 GND 0.0163f ; **FLOATING
C23 xn6/S1.t0 GND 0.03173f ; **FLOATING
C24 xn6/S1.t1 GND 0.03173f ; **FLOATING
C25 xn6/D2.t0 GND 0.03173f ; **FLOATING
C26 xn6/D2.t1 GND 0.03173f ; **FLOATING
C27 xn6/S3.t1 GND 0.03173f ; **FLOATING
C28 xn6/S3.t0 GND 0.03173f ; **FLOATING
C29 xn6/D4.t1 GND 0.03173f ; **FLOATING
C30 xn6/D4.t0 GND 0.03173f ; **FLOATING
C31 xn6/S5.t0 GND 0.03173f ; **FLOATING
C32 xn6/S5.t1 GND 0.03173f ; **FLOATING
C33 xn5/a_255_n84.t0 GND 0.14192f ; **FLOATING
C34 xn5/D0.t0 GND 0.0163f ; **FLOATING
C35 xn5/S1.t0 GND 0.03173f ; **FLOATING
C36 xn5/S1.t1 GND 0.03173f ; **FLOATING
C37 xn5/D2.t0 GND 0.03173f ; **FLOATING
C38 xn5/D2.t1 GND 0.03173f ; **FLOATING
C39 xn5/S3.t1 GND 0.03173f ; **FLOATING
C40 xn5/S3.t0 GND 0.03173f ; **FLOATING
C41 xn5/D4.t1 GND 0.03173f ; **FLOATING
C42 xn5/D4.t0 GND 0.03173f ; **FLOATING
C43 xn5/S5.t0 GND 0.03173f ; **FLOATING
C44 xn5/S5.t1 GND 0.03173f ; **FLOATING
C45 xn4/a_255_n84.t0 GND 0.14192f ; **FLOATING
C46 xn4/D0.t0 GND 0.0163f ; **FLOATING
C47 xn4/S1.t0 GND 0.03173f ; **FLOATING
C48 xn4/S1.t1 GND 0.03173f ; **FLOATING
C49 xn4/D2.t0 GND 0.03173f ; **FLOATING
C50 xn4/D2.t1 GND 0.03173f ; **FLOATING
C51 xn4/S3.t1 GND 0.03173f ; **FLOATING
C52 xn4/S3.t0 GND 0.03173f ; **FLOATING
C53 xn4/D4.t1 GND 0.03173f ; **FLOATING
C54 xn4/D4.t0 GND 0.03173f ; **FLOATING
C55 xn4/S5.t0 GND 0.03173f ; **FLOATING
C56 xn4/S5.t1 GND 0.03173f ; **FLOATING
C57 Y GND 3.79201f
C58 C GND 0.99188f
C59 VDD GND 6.51282f
C60 xp3/D.t0 GND 0.00883f ; **FLOATING
C61 xp3/S.t0 GND 0.00883f ; **FLOATING
.ends
