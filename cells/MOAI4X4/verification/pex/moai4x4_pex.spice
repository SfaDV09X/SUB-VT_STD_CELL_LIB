* NGSPICE file created from moai4x4.ext - technology: sky130A

.subckt moai4x4 A VDD GND B D C Y
X0 a_727_564.t3 a_187_564.t8 VDD.t21 VDD.t20 sky130_fd_pr__pfet_01v8 ad=0.1512 pd=1.2 as=0.1512 ps=1.2 w=0.84 l=0.2
X1 a_822_84.t15 a_413_564.t4 Y.t12 GND.t25 sky130_fd_pr__nfet_01v8 ad=0.1176 pd=1.12 as=0.1176 ps=1.12 w=0.84 l=0.28
X2 a_727_564.t5 a_413_564.t11 Y.t5 VDD.t24 sky130_fd_pr__pfet_01v8 ad=0.1176 pd=1.12 as=0.2394 ps=2.25 w=0.84 l=0.2
X3 VDD.t17 a_187_564.t11 a_727_564.t1 VDD.t16 sky130_fd_pr__pfet_01v8 ad=0.1344 pd=1.16 as=0.1176 ps=1.12 w=0.84 l=0.2
X4 Y.t14 D.t6 a_1823_564.t7 VDD.t27 sky130_fd_pr__pfet_01v8 ad=0.1512 pd=1.2 as=0.1512 ps=1.2 w=0.84 l=0.2
X5 a_1823_564.t4 C.t4 VDD.t13 VDD.t12 sky130_fd_pr__pfet_01v8 ad=0.1176 pd=1.12 as=0.1344 ps=1.16 w=0.84 l=0.2
X6 Y.t16 D.t4 a_1823_564.t9 VDD.t29 sky130_fd_pr__pfet_01v8 ad=0.2394 pd=2.25 as=0.1176 ps=1.12 w=0.84 l=0.2
X7 GND.t3 C.t3 a_822_84.t0 GND.t2 sky130_fd_pr__nfet_01v8 ad=0.1176 pd=1.12 as=0.1176 ps=1.12 w=0.84 l=0.28
X8 a_822_84.t12 D.t1 GND.t17 GND.t16 sky130_fd_pr__nfet_01v8 ad=0.1176 pd=1.12 as=0.1176 ps=1.12 w=0.84 l=0.28
X9 a_413_564.t0 B.t2 VDD.t35 VDD.t34 sky130_fd_pr__pfet_01v8 ad=0.1344 pd=1.16 as=0.1491 ps=1.195 w=0.84 l=0.21
X10 a_1823_564.t0 C.t8 VDD.t7 VDD.t6 sky130_fd_pr__pfet_01v8 ad=0.1512 pd=1.2 as=0.1512 ps=1.2 w=0.84 l=0.2
X11 VDD.t19 a_187_564.t9 a_727_564.t2 VDD.t18 sky130_fd_pr__pfet_01v8 ad=0.1512 pd=1.2 as=0.1512 ps=1.2 w=0.84 l=0.2
X12 Y.t3 a_187_564.t4 a_822_84.t7 GND.t13 sky130_fd_pr__nfet_01v8 ad=0.1176 pd=1.12 as=0.1176 ps=1.12 w=0.84 l=0.28
X13 VDD.t1 A.t1 a_187_564.t1 VDD.t0 sky130_fd_pr__pfet_01v8 ad=0.1491 pd=1.195 as=0.1491 ps=1.195 w=0.84 l=0.21
X14 a_187_564.t0 A.t2 VDD.t3 VDD.t2 sky130_fd_pr__pfet_01v8 ad=0.1491 pd=1.195 as=0.273 ps=2.33 w=0.84 l=0.21
X15 Y.t9 a_413_564.t10 a_727_564.t8 VDD.t32 sky130_fd_pr__pfet_01v8 ad=0.1512 pd=1.2 as=0.1512 ps=1.2 w=0.84 l=0.2
X16 a_822_84.t5 a_187_564.t3 Y.t1 GND.t11 sky130_fd_pr__nfet_01v8 ad=0.1176 pd=1.12 as=0.1176 ps=1.12 w=0.84 l=0.28
X17 GND.t7 C.t1 a_822_84.t2 GND.t6 sky130_fd_pr__nfet_01v8 ad=0.1176 pd=1.12 as=0.1176 ps=1.12 w=0.84 l=0.28
X18 VDD.t23 a_187_564.t7 a_727_564.t4 VDD.t22 sky130_fd_pr__pfet_01v8 ad=0.1512 pd=1.2 as=0.1512 ps=1.2 w=0.84 l=0.2
X19 a_1823_564.t2 C.t6 VDD.t9 VDD.t8 sky130_fd_pr__pfet_01v8 ad=0.1512 pd=1.2 as=0.1512 ps=1.2 w=0.84 l=0.2
X20 a_822_84.t6 a_187_564.t5 Y.t2 GND.t12 sky130_fd_pr__nfet_01v8 ad=0.1176 pd=1.12 as=0.1176 ps=1.12 w=0.84 l=0.28
X21 a_727_564.t7 a_413_564.t9 Y.t8 VDD.t31 sky130_fd_pr__pfet_01v8 ad=0.1512 pd=1.2 as=0.1512 ps=1.2 w=0.84 l=0.2
X22 Y.t4 a_187_564.t6 a_822_84.t8 GND.t14 sky130_fd_pr__nfet_01v8 ad=0.1176 pd=1.12 as=0.2394 ps=2.25 w=0.84 l=0.28
X23 Y.t6 a_413_564.t3 a_822_84.t9 GND.t15 sky130_fd_pr__nfet_01v8 ad=0.1176 pd=1.12 as=0.1176 ps=1.12 w=0.84 l=0.28
X24 a_822_84.t1 C.t2 GND.t5 GND.t4 sky130_fd_pr__nfet_01v8 ad=0.1176 pd=1.12 as=0.1176 ps=1.12 w=0.84 l=0.28
X25 a_727_564.t0 a_187_564.t10 VDD.t15 VDD.t14 sky130_fd_pr__pfet_01v8 ad=0.1512 pd=1.2 as=0.1344 ps=1.16 w=0.84 l=0.2
X26 Y.t10 a_413_564.t5 a_822_84.t14 GND.t24 sky130_fd_pr__nfet_01v8 ad=0.1176 pd=1.12 as=0.1176 ps=1.12 w=0.84 l=0.28
X27 a_187_564.t2 A.t0 GND.t1 GND.t0 sky130_fd_pr__nfet_01v8 ad=0.2394 pd=2.25 as=0.2394 ps=2.25 w=0.84 l=0.29
X28 VDD.t5 C.t7 a_1823_564.t1 VDD.t4 sky130_fd_pr__pfet_01v8 ad=0.1512 pd=1.2 as=0.1512 ps=1.2 w=0.84 l=0.2
X29 a_727_564.t9 a_413_564.t7 Y.t11 VDD.t33 sky130_fd_pr__pfet_01v8 ad=0.1512 pd=1.2 as=0.1512 ps=1.2 w=0.84 l=0.2
X30 a_413_564.t2 B.t0 GND.t27 GND.t26 sky130_fd_pr__nfet_01v8 ad=0.2394 pd=2.25 as=0.2394 ps=2.25 w=0.84 l=0.29
X31 VDD.t11 C.t5 a_1823_564.t3 VDD.t10 sky130_fd_pr__pfet_01v8 ad=0.1344 pd=1.16 as=0.1512 ps=1.2 w=0.84 l=0.2
X32 Y.t7 a_413_564.t8 a_727_564.t6 VDD.t30 sky130_fd_pr__pfet_01v8 ad=0.1512 pd=1.2 as=0.1512 ps=1.2 w=0.84 l=0.2
X33 a_1823_564.t6 D.t7 Y.t15 VDD.t26 sky130_fd_pr__pfet_01v8 ad=0.1512 pd=1.2 as=0.1512 ps=1.2 w=0.84 l=0.2
X34 a_822_84.t4 a_413_564.t6 Y.t0 GND.t10 sky130_fd_pr__nfet_01v8 ad=0.1176 pd=1.12 as=0.1176 ps=1.12 w=0.84 l=0.28
X35 GND.t21 D.t2 a_822_84.t11 GND.t20 sky130_fd_pr__nfet_01v8 ad=0.1176 pd=1.12 as=0.1176 ps=1.12 w=0.84 l=0.28
X36 a_822_84.t3 C.t0 GND.t9 GND.t8 sky130_fd_pr__nfet_01v8 ad=0.2394 pd=2.25 as=0.1176 ps=1.12 w=0.84 l=0.28
X37 VDD.t37 B.t1 a_413_564.t1 VDD.t36 sky130_fd_pr__pfet_01v8 ad=0.2394 pd=2.25 as=0.1344 ps=1.16 w=0.84 l=0.21
X38 a_1823_564.t8 D.t5 Y.t17 VDD.t28 sky130_fd_pr__pfet_01v8 ad=0.1512 pd=1.2 as=0.1512 ps=1.2 w=0.84 l=0.2
X39 Y.t13 D.t8 a_1823_564.t5 VDD.t25 sky130_fd_pr__pfet_01v8 ad=0.1512 pd=1.2 as=0.1512 ps=1.2 w=0.84 l=0.2
X40 a_822_84.t10 D.t3 GND.t19 GND.t18 sky130_fd_pr__nfet_01v8 ad=0.1176 pd=1.12 as=0.1176 ps=1.12 w=0.84 l=0.28
X41 GND.t23 D.t0 a_822_84.t13 GND.t22 sky130_fd_pr__nfet_01v8 ad=0.1176 pd=1.12 as=0.1176 ps=1.12 w=0.84 l=0.28
C0 A B 0.04542f
C1 Y VDD 0.52879f
C2 Y C 0.06261f
C3 Y D 0.33106f
C4 C VDD 0.46919f
C5 VDD D 0.48585f
C6 A Y 0
C7 C D 0.78756f
C8 B Y 0.00186f
C9 A VDD 0.21024f
C10 B VDD 0.21865f
R0 Y.n1 Y.t16 340.904
R1 Y.n13 Y.t5 340.635
R2 Y.n1 Y.n0 307.072
R3 Y.n3 Y.n2 307.072
R4 Y.n5 Y.n4 307.072
R5 Y.n15 Y.n14 307.072
R6 Y.n8 Y.n6 127.186
R7 Y.n8 Y.n7 126.647
R8 Y.n10 Y.n9 126.647
R9 Y.n12 Y.n11 126.647
R10 Y.n0 Y.t14 42.2148
R11 Y.n0 Y.t17 42.2148
R12 Y.n2 Y.t13 42.2148
R13 Y.n2 Y.t15 42.2148
R14 Y.n4 Y.t7 42.2148
R15 Y.n4 Y.t11 42.2148
R16 Y.n14 Y.t9 42.2148
R17 Y.n14 Y.t8 42.2148
R18 Y.n6 Y.t6 20.0005
R19 Y.n6 Y.t1 20.0005
R20 Y.n7 Y.t3 20.0005
R21 Y.n7 Y.t12 20.0005
R22 Y.n9 Y.t10 20.0005
R23 Y.n9 Y.t2 20.0005
R24 Y.n11 Y.t4 20.0005
R25 Y.n11 Y.t0 20.0005
R26 Y.n13 Y.n12 10.2793
R27 Y.n5 Y.n3 1.07742
R28 Y.n3 Y.n1 1.07742
R29 Y Y.n15 0.752904
R30 Y.n12 Y.n10 0.538962
R31 Y.n10 Y.n8 0.538962
R32 Y Y.n5 0.325019
R33 Y.n15 Y.n13 0.269731
R34 D.n3 D.t4 392.913
R35 D.n0 D.t5 253.05
R36 D.n4 D.t7 253.05
R37 D.n1 D.t0 188.095
R38 D.n5 D.t2 188.095
R39 D.n2 D.n1 184.476
R40 D.n6 D.n5 184.476
R41 D D.n6 162.322
R42 D.n3 D.n2 161.3
R43 D.n0 D.t6 137.37
R44 D.n4 D.t8 137.37
R45 D.n1 D.t1 98.1219
R46 D.n5 D.t3 98.1219
R47 D.n2 D.n0 98.0602
R48 D.n6 D.n4 98.0602
R49 D D.n3 0.0557885
R50 C.n2 C.t8 326.993
R51 C.n3 C.t6 253.05
R52 C.n0 C.t4 240.197
R53 C.n1 C.n0 194.46
R54 C.n5 C.n3 194.46
R55 C.n4 C.t1 188.095
R56 C.n1 C.t0 186.197
R57 C.n2 C.t3 181.361
R58 C C.n1 162.298
R59 C.n6 C.n2 162.108
R60 C.n6 C.n5 161.3
R61 C.n0 C.t5 137.37
R62 C.n3 C.t7 137.37
R63 C.n4 C.t2 98.1219
R64 C.n5 C.n4 88.0759
R65 C C.n6 0.0798269
R66 B.n1 B.t0 271.313
R67 B.n0 B.t1 233.655
R68 B B.n1 161.356
R69 B.n0 B.t2 130.829
R70 B.n1 B.n0 94.1053
R71 A.n0 A.t1 244.903
R72 A.n1 A.n0 185.915
R73 A.n1 A.t0 179.504
R74 A A.n1 161.356
R75 A.n0 A.t2 130.829
R76 VDD.t24 VDD.t36 449.209
R77 VDD.n3 VDD.n2 430.209
R78 VDD.n9 VDD.t3 429.368
R79 VDD.n10 VDD.t37 376.158
R80 VDD.n3 VDD.n1 343.325
R81 VDD.n4 VDD.n0 343.325
R82 VDD.n12 VDD.n6 343.325
R83 VDD.n11 VDD.n7 343.325
R84 VDD.n9 VDD.n8 343.325
R85 VDD.t0 VDD.t2 242.874
R86 VDD.t34 VDD.t0 242.874
R87 VDD.t32 VDD.t14 240.725
R88 VDD.t31 VDD.t32 240.725
R89 VDD.t18 VDD.t31 240.725
R90 VDD.t20 VDD.t18 240.725
R91 VDD.t30 VDD.t20 240.725
R92 VDD.t33 VDD.t22 240.725
R93 VDD.t22 VDD.t6 240.725
R94 VDD.t6 VDD.t25 240.725
R95 VDD.t25 VDD.t26 240.725
R96 VDD.t26 VDD.t4 240.725
R97 VDD.t4 VDD.t8 240.725
R98 VDD.t8 VDD.t27 240.725
R99 VDD.t27 VDD.t28 240.725
R100 VDD.t28 VDD.t10 240.725
R101 VDD.n5 VDD.t33 229.977
R102 VDD.t36 VDD.t34 227.828
R103 VDD.t14 VDD.t16 223.53
R104 VDD.t10 VDD.t12 223.53
R105 VDD.t16 VDD.t24 206.335
R106 VDD.t12 VDD.t29 206.335
R107 VDD.n12 VDD.n11 86.8853
R108 VDD.n4 VDD.n3 86.8853
R109 VDD.n11 VDD.n10 58.9581
R110 VDD.n13 VDD.n4 53.3338
R111 VDD.n2 VDD.t11 42.2148
R112 VDD.n1 VDD.t5 42.2148
R113 VDD.n1 VDD.t9 42.2148
R114 VDD.n0 VDD.t23 42.2148
R115 VDD.n0 VDD.t7 42.2148
R116 VDD.n6 VDD.t19 42.2148
R117 VDD.n6 VDD.t21 42.2148
R118 VDD.n7 VDD.t15 42.2148
R119 VDD.n8 VDD.t35 42.2148
R120 VDD.n10 VDD.n9 41.1157
R121 VDD.n8 VDD.t1 41.0422
R122 VDD.n13 VDD.n12 33.552
R123 VDD.n2 VDD.t13 32.8338
R124 VDD.n7 VDD.t17 32.8338
R125 VDD.n5 VDD.t30 10.7471
R126 VDD.n13 VDD.n5 8.81002
R127 VDD VDD.n13 2.14261
R128 GND.t14 GND.t26 4643.44
R129 GND.t26 GND.t0 2037.7
R130 GND.t10 GND.t14 1009.84
R131 GND.t24 GND.t10 1009.84
R132 GND.t12 GND.t24 1009.84
R133 GND.t13 GND.t12 1009.84
R134 GND.t25 GND.t13 1009.84
R135 GND.t15 GND.t11 1009.84
R136 GND.t11 GND.t2 1009.84
R137 GND.t2 GND.t18 1009.84
R138 GND.t18 GND.t20 1009.84
R139 GND.t20 GND.t4 1009.84
R140 GND.t4 GND.t6 1009.84
R141 GND.t6 GND.t16 1009.84
R142 GND.t16 GND.t22 1009.84
R143 GND.t22 GND.t8 1009.84
R144 GND.n7 GND.t15 964.755
R145 GND.n9 GND.n8 220.51
R146 GND.n8 GND.t1 207.155
R147 GND.n4 GND.n3 186.767
R148 GND.n8 GND.t27 163.325
R149 GND.n6 GND.n0 143.325
R150 GND.n5 GND.n1 143.325
R151 GND.n4 GND.n2 143.325
R152 GND.n9 GND.n6 75.0551
R153 GND.n7 GND.t25 45.0825
R154 GND.n6 GND.n5 43.4429
R155 GND.n5 GND.n4 43.4429
R156 GND.n9 GND.n7 27.8576
R157 GND.n0 GND.t3 20.0005
R158 GND.n0 GND.t19 20.0005
R159 GND.n1 GND.t21 20.0005
R160 GND.n1 GND.t5 20.0005
R161 GND.n2 GND.t7 20.0005
R162 GND.n2 GND.t17 20.0005
R163 GND.n3 GND.t23 20.0005
R164 GND.n3 GND.t9 20.0005
R165 GND GND.n9 2.14261
R166 a_822_84.n1 a_822_84.t8 156.379
R167 a_822_84.t3 a_822_84.n13 127.609
R168 a_822_84.n13 a_822_84.n12 107.072
R169 a_822_84.n11 a_822_84.n10 107.072
R170 a_822_84.n9 a_822_84.n8 107.072
R171 a_822_84.n7 a_822_84.n6 107.072
R172 a_822_84.n5 a_822_84.n4 107.072
R173 a_822_84.n3 a_822_84.n2 107.072
R174 a_822_84.n1 a_822_84.n0 107.072
R175 a_822_84.n12 a_822_84.t12 20.0005
R176 a_822_84.n12 a_822_84.t13 20.0005
R177 a_822_84.n10 a_822_84.t1 20.0005
R178 a_822_84.n10 a_822_84.t2 20.0005
R179 a_822_84.n8 a_822_84.t10 20.0005
R180 a_822_84.n8 a_822_84.t11 20.0005
R181 a_822_84.n6 a_822_84.t5 20.0005
R182 a_822_84.n6 a_822_84.t0 20.0005
R183 a_822_84.n4 a_822_84.t15 20.0005
R184 a_822_84.n4 a_822_84.t9 20.0005
R185 a_822_84.n2 a_822_84.t6 20.0005
R186 a_822_84.n2 a_822_84.t7 20.0005
R187 a_822_84.n0 a_822_84.t4 20.0005
R188 a_822_84.n0 a_822_84.t14 20.0005
R189 a_822_84.n3 a_822_84.n1 0.538962
R190 a_822_84.n5 a_822_84.n3 0.538962
R191 a_822_84.n7 a_822_84.n5 0.538962
R192 a_822_84.n9 a_822_84.n7 0.538962
R193 a_822_84.n11 a_822_84.n9 0.538962
R194 a_822_84.n13 a_822_84.n11 0.538962
R195 a_1823_564.n2 a_1823_564.n0 327.187
R196 a_1823_564.n7 a_1823_564.n6 327.147
R197 a_1823_564.n6 a_1823_564.n5 326.647
R198 a_1823_564.n4 a_1823_564.n3 326.647
R199 a_1823_564.n2 a_1823_564.n1 326.647
R200 a_1823_564.n5 a_1823_564.t8 42.2148
R201 a_1823_564.n5 a_1823_564.t3 42.2148
R202 a_1823_564.n3 a_1823_564.t2 42.2148
R203 a_1823_564.n3 a_1823_564.t7 42.2148
R204 a_1823_564.n1 a_1823_564.t6 42.2148
R205 a_1823_564.n1 a_1823_564.t1 42.2148
R206 a_1823_564.n0 a_1823_564.t0 42.2148
R207 a_1823_564.n0 a_1823_564.t5 42.2148
R208 a_1823_564.t4 a_1823_564.n7 32.8338
R209 a_1823_564.n7 a_1823_564.t9 32.8338
R210 a_1823_564.n4 a_1823_564.n2 0.538962
R211 a_1823_564.n6 a_1823_564.n4 0.538962
R212 a_727_564.n2 a_727_564.n0 327.187
R213 a_727_564.n6 a_727_564.n5 327.147
R214 a_727_564.n7 a_727_564.n6 326.647
R215 a_727_564.n2 a_727_564.n1 326.647
R216 a_727_564.n4 a_727_564.n3 326.647
R217 a_727_564.t0 a_727_564.n7 42.2148
R218 a_727_564.n7 a_727_564.t8 42.2148
R219 a_727_564.n0 a_727_564.t9 42.2148
R220 a_727_564.n0 a_727_564.t4 42.2148
R221 a_727_564.n1 a_727_564.t3 42.2148
R222 a_727_564.n1 a_727_564.t6 42.2148
R223 a_727_564.n3 a_727_564.t7 42.2148
R224 a_727_564.n3 a_727_564.t2 42.2148
R225 a_727_564.n5 a_727_564.t5 32.8338
R226 a_727_564.n5 a_727_564.t1 32.8338
R227 a_727_564.n6 a_727_564.n4 0.538962
R228 a_727_564.n4 a_727_564.n2 0.538962
R229 a_187_564.n9 a_187_564.n8 317.158
R230 a_187_564.n0 a_187_564.t3 277.76
R231 a_187_564.n6 a_187_564.t6 277.76
R232 a_187_564.n1 a_187_564.t8 253.05
R233 a_187_564.n5 a_187_564.t11 240.197
R234 a_187_564.n0 a_187_564.t7 230.594
R235 a_187_564.n2 a_187_564.t4 188.095
R236 a_187_564.n3 a_187_564.n2 184.476
R237 a_187_564.n4 a_187_564.n0 162.377
R238 a_187_564.n4 a_187_564.n3 161.3
R239 a_187_564.n7 a_187_564.n6 161.3
R240 a_187_564.n1 a_187_564.t9 137.37
R241 a_187_564.n5 a_187_564.t10 137.37
R242 a_187_564.n8 a_187_564.t2 127.072
R243 a_187_564.n2 a_187_564.t5 98.1219
R244 a_187_564.n3 a_187_564.n1 98.0602
R245 a_187_564.n6 a_187_564.n5 93.2237
R246 a_187_564.n9 a_187_564.t0 42.2148
R247 a_187_564.t1 a_187_564.n9 41.0422
R248 a_187_564.n8 a_187_564.n7 11.2793
R249 a_187_564.n7 a_187_564.n4 0.808192
R250 a_413_564.n7 a_413_564.t11 488.293
R251 a_413_564.n9 a_413_564.n8 332.488
R252 a_413_564.n0 a_413_564.t7 253.05
R253 a_413_564.n3 a_413_564.t9 253.05
R254 a_413_564.n2 a_413_564.n0 194.46
R255 a_413_564.n5 a_413_564.n3 194.46
R256 a_413_564.n1 a_413_564.t3 188.095
R257 a_413_564.n4 a_413_564.t5 188.095
R258 a_413_564.n6 a_413_564.n2 162.377
R259 a_413_564.n6 a_413_564.n5 161.3
R260 a_413_564.n8 a_413_564.t2 152.286
R261 a_413_564.n0 a_413_564.t8 137.37
R262 a_413_564.n3 a_413_564.t10 137.37
R263 a_413_564.n1 a_413_564.t4 98.1219
R264 a_413_564.n4 a_413_564.t6 98.1219
R265 a_413_564.n2 a_413_564.n1 88.0759
R266 a_413_564.n5 a_413_564.n4 88.0759
R267 a_413_564.n9 a_413_564.t0 42.2148
R268 a_413_564.t1 a_413_564.n9 32.8338
R269 a_413_564.n8 a_413_564.n7 4.61588
R270 a_413_564.n7 a_413_564.n6 0.7505
C11 Y GND 0.78247f
C12 D GND 0.92982f
C13 C GND 0.9669f
C14 B GND 0.26245f
C15 A GND 0.3073f
C16 VDD GND 5.33946f
C17 a_413_564.t0 GND 0.03303f ; **FLOATING
C18 a_413_564.t2 GND 0.11387f ; **FLOATING
C19 a_413_564.t7 GND 0.09274f ; **FLOATING
C20 a_413_564.t8 GND 0.07296f ; **FLOATING
C21 a_413_564.n0 GND 0.09586f ; **FLOATING
C22 a_413_564.t3 GND 0.1276f ; **FLOATING
C23 a_413_564.t4 GND 0.10215f ; **FLOATING
C24 a_413_564.n1 GND 0.09287f ; **FLOATING
C25 a_413_564.n2 GND 0.07382f ; **FLOATING
C26 a_413_564.t9 GND 0.09274f ; **FLOATING
C27 a_413_564.t10 GND 0.07296f ; **FLOATING
C28 a_413_564.n3 GND 0.09586f ; **FLOATING
C29 a_413_564.t5 GND 0.1276f ; **FLOATING
C30 a_413_564.t6 GND 0.10215f ; **FLOATING
C31 a_413_564.n4 GND 0.09287f ; **FLOATING
C32 a_413_564.n5 GND 0.0727f ; **FLOATING
C33 a_413_564.n6 GND 0.40631f ; **FLOATING
C34 a_413_564.t11 GND 0.13813f ; **FLOATING
C35 a_413_564.n7 GND 0.21802f ; **FLOATING
C36 a_413_564.n8 GND 0.8082f ; **FLOATING
C37 a_413_564.n9 GND 0.06796f ; **FLOATING
C38 a_413_564.t1 GND 0.02569f ; **FLOATING
C39 a_187_564.t0 GND 0.03106f ; **FLOATING
C40 a_187_564.t7 GND 0.08499f ; **FLOATING
C41 a_187_564.t3 GND 0.1401f ; **FLOATING
C42 a_187_564.n0 GND 0.11855f ; **FLOATING
C43 a_187_564.t8 GND 0.0872f ; **FLOATING
C44 a_187_564.t9 GND 0.06861f ; **FLOATING
C45 a_187_564.n1 GND 0.07409f ; **FLOATING
C46 a_187_564.t4 GND 0.11999f ; **FLOATING
C47 a_187_564.t5 GND 0.09605f ; **FLOATING
C48 a_187_564.n2 GND 0.10346f ; **FLOATING
C49 a_187_564.n3 GND 0.06827f ; **FLOATING
C50 a_187_564.n4 GND 0.38847f ; **FLOATING
C51 a_187_564.t11 GND 0.08549f ; **FLOATING
C52 a_187_564.t10 GND 0.06861f ; **FLOATING
C53 a_187_564.n5 GND 0.07295f ; **FLOATING
C54 a_187_564.t6 GND 0.1401f ; **FLOATING
C55 a_187_564.n6 GND 0.09336f ; **FLOATING
C56 a_187_564.n7 GND 0.32057f ; **FLOATING
C57 a_187_564.t2 GND 0.09255f ; **FLOATING
C58 a_187_564.n8 GND 0.81133f ; **FLOATING
C59 a_187_564.n9 GND 0.07103f ; **FLOATING
C60 a_187_564.t1 GND 0.0302f ; **FLOATING
C61 a_727_564.t8 GND 0.04757f ; **FLOATING
C62 a_727_564.t4 GND 0.04757f ; **FLOATING
C63 a_727_564.t9 GND 0.04757f ; **FLOATING
C64 a_727_564.n0 GND 0.10309f ; **FLOATING
C65 a_727_564.t6 GND 0.04757f ; **FLOATING
C66 a_727_564.t3 GND 0.04757f ; **FLOATING
C67 a_727_564.n1 GND 0.10275f ; **FLOATING
C68 a_727_564.n2 GND 0.47379f ; **FLOATING
C69 a_727_564.t2 GND 0.04757f ; **FLOATING
C70 a_727_564.t7 GND 0.04757f ; **FLOATING
C71 a_727_564.n3 GND 0.10275f ; **FLOATING
C72 a_727_564.n4 GND 0.26978f ; **FLOATING
C73 a_727_564.t1 GND 0.037f ; **FLOATING
C74 a_727_564.t5 GND 0.037f ; **FLOATING
C75 a_727_564.n5 GND 0.08191f ; **FLOATING
C76 a_727_564.n6 GND 0.46073f ; **FLOATING
C77 a_727_564.n7 GND 0.10275f ; **FLOATING
C78 a_727_564.t0 GND 0.04757f ; **FLOATING
C79 a_1823_564.t9 GND 0.03571f ; **FLOATING
C80 a_1823_564.t5 GND 0.04592f ; **FLOATING
C81 a_1823_564.t0 GND 0.04592f ; **FLOATING
C82 a_1823_564.n0 GND 0.0995f ; **FLOATING
C83 a_1823_564.t1 GND 0.04592f ; **FLOATING
C84 a_1823_564.t6 GND 0.04592f ; **FLOATING
C85 a_1823_564.n1 GND 0.09917f ; **FLOATING
C86 a_1823_564.n2 GND 0.45728f ; **FLOATING
C87 a_1823_564.t7 GND 0.04592f ; **FLOATING
C88 a_1823_564.t2 GND 0.04592f ; **FLOATING
C89 a_1823_564.n3 GND 0.09917f ; **FLOATING
C90 a_1823_564.n4 GND 0.26039f ; **FLOATING
C91 a_1823_564.t3 GND 0.04592f ; **FLOATING
C92 a_1823_564.t8 GND 0.04592f ; **FLOATING
C93 a_1823_564.n5 GND 0.09917f ; **FLOATING
C94 a_1823_564.n6 GND 0.44468f ; **FLOATING
C95 a_1823_564.n7 GND 0.07906f ; **FLOATING
C96 a_1823_564.t4 GND 0.03571f ; **FLOATING
C97 a_822_84.t8 GND 0.08815f ; **FLOATING
C98 a_822_84.t14 GND 0.01972f ; **FLOATING
C99 a_822_84.t4 GND 0.01972f ; **FLOATING
C100 a_822_84.n0 GND 0.04513f ; **FLOATING
C101 a_822_84.n1 GND 0.33795f ; **FLOATING
C102 a_822_84.t7 GND 0.01972f ; **FLOATING
C103 a_822_84.t6 GND 0.01972f ; **FLOATING
C104 a_822_84.n2 GND 0.04513f ; **FLOATING
C105 a_822_84.n3 GND 0.14215f ; **FLOATING
C106 a_822_84.t9 GND 0.01972f ; **FLOATING
C107 a_822_84.t15 GND 0.01972f ; **FLOATING
C108 a_822_84.n4 GND 0.04513f ; **FLOATING
C109 a_822_84.n5 GND 0.14215f ; **FLOATING
C110 a_822_84.t0 GND 0.01972f ; **FLOATING
C111 a_822_84.t5 GND 0.01972f ; **FLOATING
C112 a_822_84.n6 GND 0.04513f ; **FLOATING
C113 a_822_84.n7 GND 0.14215f ; **FLOATING
C114 a_822_84.t11 GND 0.01972f ; **FLOATING
C115 a_822_84.t10 GND 0.01972f ; **FLOATING
C116 a_822_84.n8 GND 0.04513f ; **FLOATING
C117 a_822_84.n9 GND 0.14215f ; **FLOATING
C118 a_822_84.t2 GND 0.01972f ; **FLOATING
C119 a_822_84.t1 GND 0.01972f ; **FLOATING
C120 a_822_84.n10 GND 0.04513f ; **FLOATING
C121 a_822_84.n11 GND 0.14215f ; **FLOATING
C122 a_822_84.t13 GND 0.01972f ; **FLOATING
C123 a_822_84.t12 GND 0.01972f ; **FLOATING
C124 a_822_84.n12 GND 0.04513f ; **FLOATING
C125 a_822_84.n13 GND 0.25936f ; **FLOATING
C126 a_822_84.t3 GND 0.07605f ; **FLOATING
C127 VDD.t7 GND 0.00779f ; **FLOATING
C128 VDD.t23 GND 0.00779f ; **FLOATING
C129 VDD.n0 GND 0.0176f ; **FLOATING
C130 VDD.t9 GND 0.00779f ; **FLOATING
C131 VDD.t5 GND 0.00779f ; **FLOATING
C132 VDD.n1 GND 0.0176f ; **FLOATING
C133 VDD.t13 GND 0.00606f ; **FLOATING
C134 VDD.t11 GND 0.00779f ; **FLOATING
C135 VDD.n2 GND 0.03601f ; **FLOATING
C136 VDD.n3 GND 0.17328f ; **FLOATING
C137 VDD.n4 GND 0.07902f ; **FLOATING
C138 VDD.t29 GND 0.28593f ; **FLOATING
C139 VDD.t12 GND 0.11392f ; **FLOATING
C140 VDD.t10 GND 0.12303f ; **FLOATING
C141 VDD.t28 GND 0.12759f ; **FLOATING
C142 VDD.t27 GND 0.12759f ; **FLOATING
C143 VDD.t8 GND 0.12759f ; **FLOATING
C144 VDD.t4 GND 0.12759f ; **FLOATING
C145 VDD.t26 GND 0.12759f ; **FLOATING
C146 VDD.t25 GND 0.12759f ; **FLOATING
C147 VDD.t6 GND 0.12759f ; **FLOATING
C148 VDD.t22 GND 0.12759f ; **FLOATING
C149 VDD.t33 GND 0.12474f ; **FLOATING
C150 VDD.t2 GND 0.30587f ; **FLOATING
C151 VDD.t0 GND 0.12873f ; **FLOATING
C152 VDD.t34 GND 0.12474f ; **FLOATING
C153 VDD.t36 GND 0.17942f ; **FLOATING
C154 VDD.t24 GND 0.17373f ; **FLOATING
C155 VDD.t16 GND 0.11392f ; **FLOATING
C156 VDD.t14 GND 0.12303f ; **FLOATING
C157 VDD.t32 GND 0.12759f ; **FLOATING
C158 VDD.t31 GND 0.12759f ; **FLOATING
C159 VDD.t18 GND 0.12759f ; **FLOATING
C160 VDD.t20 GND 0.12759f ; **FLOATING
C161 VDD.t30 GND 0.06664f ; **FLOATING
C162 VDD.n5 GND 0.27845f ; **FLOATING
C163 VDD.t21 GND 0.00779f ; **FLOATING
C164 VDD.t19 GND 0.00779f ; **FLOATING
C165 VDD.n6 GND 0.0176f ; **FLOATING
C166 VDD.t15 GND 0.00779f ; **FLOATING
C167 VDD.t17 GND 0.00606f ; **FLOATING
C168 VDD.n7 GND 0.01587f ; **FLOATING
C169 VDD.t37 GND 0.0249f ; **FLOATING
C170 VDD.t35 GND 0.00779f ; **FLOATING
C171 VDD.t1 GND 0.00758f ; **FLOATING
C172 VDD.n8 GND 0.01739f ; **FLOATING
C173 VDD.t3 GND 0.03288f ; **FLOATING
C174 VDD.n9 GND 0.10021f ; **FLOATING
C175 VDD.n10 GND 0.06321f ; **FLOATING
C176 VDD.n11 GND 0.08148f ; **FLOATING
C177 VDD.n12 GND 0.07034f ; **FLOATING
C178 VDD.n13 GND 0.73716f ; **FLOATING
C179 A.t1 GND 0.05919f ; **FLOATING
C180 A.t2 GND 0.04655f ; **FLOATING
C181 A.n0 GND 0.06028f ; **FLOATING
C182 A.t0 GND 0.08097f ; **FLOATING
C183 A.n1 GND 0.06374f ; **FLOATING
C184 B.t1 GND 0.06835f ; **FLOATING
C185 B.t2 GND 0.05468f ; **FLOATING
C186 B.n0 GND 0.05754f ; **FLOATING
C187 B.t0 GND 0.11091f ; **FLOATING
C188 B.n1 GND 0.07189f ; **FLOATING
C189 C.t4 GND 0.08015f ; **FLOATING
C190 C.t5 GND 0.06432f ; **FLOATING
C191 C.n0 GND 0.08379f ; **FLOATING
C192 C.t0 GND 0.11337f ; **FLOATING
C193 C.n1 GND 0.09093f ; **FLOATING
C194 C.t8 GND 0.09495f ; **FLOATING
C195 C.t3 GND 0.11253f ; **FLOATING
C196 C.n2 GND 0.11431f ; **FLOATING
C197 C.t6 GND 0.08175f ; **FLOATING
C198 C.t7 GND 0.06432f ; **FLOATING
C199 C.n3 GND 0.0845f ; **FLOATING
C200 C.t1 GND 0.11248f ; **FLOATING
C201 C.t2 GND 0.09005f ; **FLOATING
C202 C.n4 GND 0.08187f ; **FLOATING
C203 C.n5 GND 0.06409f ; **FLOATING
C204 C.n6 GND 0.23264f ; **FLOATING
C205 D.t4 GND 0.10654f ; **FLOATING
C206 D.t5 GND 0.08127f ; **FLOATING
C207 D.t6 GND 0.06394f ; **FLOATING
C208 D.n0 GND 0.06905f ; **FLOATING
C209 D.t0 GND 0.11182f ; **FLOATING
C210 D.t1 GND 0.08952f ; **FLOATING
C211 D.n1 GND 0.09642f ; **FLOATING
C212 D.n2 GND 0.06363f ; **FLOATING
C213 D.n3 GND 0.31111f ; **FLOATING
C214 D.t7 GND 0.08127f ; **FLOATING
C215 D.t8 GND 0.06394f ; **FLOATING
C216 D.n4 GND 0.06905f ; **FLOATING
C217 D.t2 GND 0.11182f ; **FLOATING
C218 D.t3 GND 0.08952f ; **FLOATING
C219 D.n5 GND 0.09642f ; **FLOATING
C220 D.n6 GND 0.06452f ; **FLOATING
C221 Y.t16 GND 0.12322f ; **FLOATING
C222 Y.t17 GND 0.04074f ; **FLOATING
C223 Y.t14 GND 0.04074f ; **FLOATING
C224 Y.n0 GND 0.08466f ; **FLOATING
C225 Y.n1 GND 0.63452f ; **FLOATING
C226 Y.t15 GND 0.04074f ; **FLOATING
C227 Y.t13 GND 0.04074f ; **FLOATING
C228 Y.n2 GND 0.08466f ; **FLOATING
C229 Y.n3 GND 0.39123f ; **FLOATING
C230 Y.t11 GND 0.04074f ; **FLOATING
C231 Y.t7 GND 0.04074f ; **FLOATING
C232 Y.n4 GND 0.08466f ; **FLOATING
C233 Y.n5 GND 0.28161f ; **FLOATING
C234 Y.t5 GND 0.12294f ; **FLOATING
C235 Y.t1 GND 0.03168f ; **FLOATING
C236 Y.t6 GND 0.03168f ; **FLOATING
C237 Y.n6 GND 0.08086f ; **FLOATING
C238 Y.t12 GND 0.03168f ; **FLOATING
C239 Y.t3 GND 0.03168f ; **FLOATING
C240 Y.n7 GND 0.08016f ; **FLOATING
C241 Y.n8 GND 0.38471f ; **FLOATING
C242 Y.t2 GND 0.03168f ; **FLOATING
C243 Y.t10 GND 0.03168f ; **FLOATING
C244 Y.n9 GND 0.08016f ; **FLOATING
C245 Y.n10 GND 0.22072f ; **FLOATING
C246 Y.t0 GND 0.03168f ; **FLOATING
C247 Y.t4 GND 0.03168f ; **FLOATING
C248 Y.n11 GND 0.08016f ; **FLOATING
C249 Y.n12 GND 0.37343f ; **FLOATING
C250 Y.n13 GND 0.56999f ; **FLOATING
C251 Y.t8 GND 0.04074f ; **FLOATING
C252 Y.t9 GND 0.04074f ; **FLOATING
C253 Y.n14 GND 0.08466f ; **FLOATING
C254 Y.n15 GND 0.22627f ; **FLOATING
.ends
