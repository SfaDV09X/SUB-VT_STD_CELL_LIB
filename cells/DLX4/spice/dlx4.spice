** sch_path: /foss/designs/dlx4.sch
.subckt dlx4 D VDD GND CLK QB Q
*.PININFO D:I VDD:B GND:B CLK:I QB:O Q:O
XM1 D CLKB net1 VDD sky130_fd_pr__pfet_01v8 L=0.19 W=3.36 nf=4
XM2 D CLK net1 GND sky130_fd_pr__nfet_01v8 L=0.19 W=1.68 nf=2
XM3 CLKB CLK VDD VDD sky130_fd_pr__pfet_01v8 L=0.21 W=3.36 nf=4
XM4 CLKB CLK GND GND sky130_fd_pr__nfet_01v8 L=0.29 W=1.68 nf=2
XM9 QB net1 VDD VDD sky130_fd_pr__pfet_01v8 L=0.21 W=3.36 nf=4
XM8 QB net1 GND GND sky130_fd_pr__nfet_01v8 L=0.29 W=1.68 nf=2
XM5 Q QB VDD VDD sky130_fd_pr__pfet_01v8 L=0.21 W=3.36 nf=4
XM6 Q QB GND GND sky130_fd_pr__nfet_01v8 L=0.29 W=1.68 nf=2
XM7 net1 CLK Q VDD sky130_fd_pr__pfet_01v8 L=0.47 W=0.84 nf=1
XM10 net1 CLKB Q GND sky130_fd_pr__nfet_01v8 L=0.47 W=0.42 nf=1
.ends
