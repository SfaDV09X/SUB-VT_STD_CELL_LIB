* NGSPICE file created from dlx4.ext - technology: sky130A

.subckt dlx4 D VDD GND CLK QB Q
X0 VDD.t19 a_607_84.t12 QB.t5 VDD.t18 sky130_fd_pr__pfet_01v8 ad=0.1512 pd=1.2 as=0.1512 ps=1.2 w=0.84 l=0.21
X1 Q.t4 QB.t11 VDD.t1 VDD.t0 sky130_fd_pr__pfet_01v8 ad=0.1176 pd=1.12 as=0.1344 ps=1.16 w=0.84 l=0.21
X2 Q.t7 a_178_564.t6 a_607_84.t4 GND.t8 sky130_fd_pr__nfet_01v8 ad=0.1197 pd=1.41 as=0.1197 ps=1.41 w=0.42 l=0.47
X3 a_607_84.t0 a_178_564.t7 D.t2 VDD.t14 sky130_fd_pr__pfet_01v8 ad=0.1176 pd=1.12 as=0.1176 ps=1.12 w=0.84 l=0.19
X4 D.t5 a_178_564.t10 a_607_84.t3 VDD.t17 sky130_fd_pr__pfet_01v8 ad=0.1176 pd=1.12 as=0.2394 ps=2.25 w=0.84 l=0.19
X5 VDD.t7 QB.t8 Q.t6 VDD.t6 sky130_fd_pr__pfet_01v8 ad=0.2394 pd=2.25 as=0.1176 ps=1.12 w=0.84 l=0.21
X6 GND.t5 a_607_84.t8 QB.t1 GND.t4 sky130_fd_pr__nfet_01v8 ad=0.1176 pd=1.12 as=0.1176 ps=1.12 w=0.84 l=0.29
X7 a_178_564.t0 CLK.t3 GND.t10 GND.t9 sky130_fd_pr__nfet_01v8 ad=0.1176 pd=1.12 as=0.2394 ps=2.25 w=0.84 l=0.29
X8 a_607_84.t7 CLK.t0 D.t1 GND.t14 sky130_fd_pr__nfet_01v8 ad=0.2394 pd=2.25 as=0.1176 ps=1.12 w=0.84 l=0.19
X9 GND.t3 QB.t6 Q.t2 GND.t2 sky130_fd_pr__nfet_01v8 ad=0.2394 pd=2.25 as=0.1176 ps=1.12 w=0.84 l=0.29
X10 D.t3 a_178_564.t8 a_607_84.t1 VDD.t15 sky130_fd_pr__pfet_01v8 ad=0.1176 pd=1.12 as=0.1176 ps=1.12 w=0.84 l=0.19
X11 QB.t4 a_607_84.t11 VDD.t13 VDD.t12 sky130_fd_pr__pfet_01v8 ad=0.1512 pd=1.2 as=0.1512 ps=1.2 w=0.84 l=0.21
X12 VDD.t3 QB.t10 Q.t1 VDD.t2 sky130_fd_pr__pfet_01v8 ad=0.1176 pd=1.12 as=0.1176 ps=1.12 w=0.84 l=0.21
X13 QB.t2 a_607_84.t9 GND.t7 GND.t6 sky130_fd_pr__nfet_01v8 ad=0.1176 pd=1.12 as=0.2394 ps=2.25 w=0.84 l=0.29
X14 VDD.t11 a_607_84.t10 QB.t3 VDD.t10 sky130_fd_pr__pfet_01v8 ad=0.1344 pd=1.16 as=0.1512 ps=1.2 w=0.84 l=0.21
X15 a_178_564.t4 CLK.t6 VDD.t25 VDD.t24 sky130_fd_pr__pfet_01v8 ad=0.1176 pd=1.12 as=0.1344 ps=1.16 w=0.84 l=0.21
X16 Q.t3 QB.t7 GND.t1 GND.t0 sky130_fd_pr__nfet_01v8 ad=0.1176 pd=1.12 as=0.1176 ps=1.12 w=0.84 l=0.29
X17 GND.t12 CLK.t2 a_178_564.t1 GND.t11 sky130_fd_pr__nfet_01v8 ad=0.2394 pd=2.25 as=0.1176 ps=1.12 w=0.84 l=0.29
X18 a_178_564.t2 CLK.t8 VDD.t21 VDD.t20 sky130_fd_pr__pfet_01v8 ad=0.1512 pd=1.2 as=0.273 ps=2.33 w=0.84 l=0.21
X19 a_607_84.t2 a_178_564.t9 D.t4 VDD.t16 sky130_fd_pr__pfet_01v8 ad=0.1176 pd=1.12 as=0.1176 ps=1.12 w=0.84 l=0.19
X20 Q.t5 CLK.t4 a_607_84.t5 VDD.t28 sky130_fd_pr__pfet_01v8 ad=0.2394 pd=2.25 as=0.1176 ps=1.12 w=0.84 l=0.47
X21 Q.t0 QB.t9 VDD.t5 VDD.t4 sky130_fd_pr__pfet_01v8 ad=0.1176 pd=1.12 as=0.1176 ps=1.12 w=0.84 l=0.21
X22 VDD.t23 CLK.t7 a_178_564.t3 VDD.t22 sky130_fd_pr__pfet_01v8 ad=0.1344 pd=1.16 as=0.1512 ps=1.2 w=0.84 l=0.21
X23 QB.t0 a_607_84.t13 VDD.t9 VDD.t8 sky130_fd_pr__pfet_01v8 ad=0.1512 pd=1.2 as=0.273 ps=2.33 w=0.84 l=0.21
X24 VDD.t27 CLK.t5 a_178_564.t5 VDD.t26 sky130_fd_pr__pfet_01v8 ad=0.2394 pd=2.25 as=0.1176 ps=1.12 w=0.84 l=0.21
X25 D.t0 CLK.t1 a_607_84.t6 GND.t13 sky130_fd_pr__nfet_01v8 ad=0.1176 pd=1.12 as=0.2394 ps=2.25 w=0.84 l=0.19
C0 QB VDD 0.94049f
C1 QB Q 0.67821f
C2 CLK D 0.09596f
C3 VDD Q 0.7964f
C4 QB D 0.00803f
C5 VDD D 0.24657f
C6 D Q 0.04995f
C7 QB CLK 0.00118f
C8 CLK VDD 0.56115f
C9 CLK Q 0.03104f
R0 Q.n5 Q.t5 340.534
R1 Q.n2 Q.n0 307.543
R2 Q.n2 Q.n1 307.072
R3 Q.n4 Q.t7 243.335
R4 Q.n4 Q.n3 127.739
R5 Q.n0 Q.t0 32.8338
R6 Q.n0 Q.t6 32.8338
R7 Q.n1 Q.t4 32.8338
R8 Q.n1 Q.t1 32.8338
R9 Q.n3 Q.t3 20.0005
R10 Q.n3 Q.t2 20.0005
R11 Q.n5 Q.n4 10.2793
R12 Q Q.n2 1.38752
R13 Q Q.n5 0.214442
R14 D D.n0 326.928
R15 D.n3 D.n2 326.647
R16 D.n3 D.n1 137.119
R17 D.n0 D.t3 32.8338
R18 D.n0 D.t2 32.8338
R19 D.n2 D.t5 32.8338
R20 D.n2 D.t4 32.8338
R21 D.n1 D.t0 20.0005
R22 D.n1 D.t1 20.0005
R23 D D.n3 0.171173
R24 QB.n9 QB.n8 333.493
R25 QB.n5 QB.n3 326.921
R26 QB.n5 QB.n4 326.921
R27 QB QB.n2 255.578
R28 QB.n0 QB.t8 243.296
R29 QB.n8 QB.t6 184.712
R30 QB.n1 QB.n0 134.96
R31 QB.n2 QB.t11 130.829
R32 QB.n7 QB.n6 112.48
R33 QB.n2 QB.n1 112.468
R34 QB.n1 QB.t10 96.4005
R35 QB.n0 QB.t9 96.4005
R36 QB.n8 QB.t7 94.7384
R37 QB.n3 QB.t4 42.2148
R38 QB.n3 QB.t3 42.2148
R39 QB.n4 QB.t0 42.2148
R40 QB.n4 QB.t5 42.2148
R41 QB.n6 QB.t2 20.0005
R42 QB.n6 QB.t1 20.0005
R43 QB.n7 QB.n5 5.14473
R44 QB.n9 QB.n7 4.63752
R45 QB QB.n9 0.356269
R46 CLK.n1 CLK.t4 306.872
R47 CLK.n1 CLK.n0 253.319
R48 CLK.n2 CLK.t5 243.296
R49 CLK.n0 CLK.t0 234.573
R50 CLK.n6 CLK.n4 185.915
R51 CLK.n5 CLK.t2 184.712
R52 CLK CLK.n6 162.397
R53 CLK.n3 CLK.n2 147.814
R54 CLK.n0 CLK.t1 144.601
R55 CLK.n4 CLK.n3 138.173
R56 CLK.n4 CLK.t8 130.829
R57 CLK.n3 CLK.t7 96.4005
R58 CLK.n2 CLK.t6 96.4005
R59 CLK.n5 CLK.t3 94.7384
R60 CLK.n6 CLK.n5 84.766
R61 CLK CLK.n1 0.168769
R62 VDD.n7 VDD.t8 754.413
R63 VDD.t17 VDD.t26 447.06
R64 VDD.n9 VDD.t21 429.757
R65 VDD.n3 VDD.t7 414.17
R66 VDD.n6 VDD.t9 385.538
R67 VDD.n10 VDD.t27 376.158
R68 VDD.n3 VDD.n2 343.325
R69 VDD.n4 VDD.n1 343.325
R70 VDD.n5 VDD.n0 343.325
R71 VDD.n9 VDD.n8 343.325
R72 VDD.n7 VDD.t28 333.146
R73 VDD.t28 VDD.t14 262.217
R74 VDD.t22 VDD.t20 245.024
R75 VDD.t8 VDD.t18 245.024
R76 VDD.t18 VDD.t12 245.024
R77 VDD.t12 VDD.t10 245.024
R78 VDD.t24 VDD.t22 227.828
R79 VDD.t10 VDD.t0 227.828
R80 VDD.t26 VDD.t24 210.633
R81 VDD.t0 VDD.t2 210.633
R82 VDD.t2 VDD.t4 210.633
R83 VDD.t4 VDD.t6 210.633
R84 VDD.t16 VDD.t17 202.036
R85 VDD.t15 VDD.t16 202.036
R86 VDD.t14 VDD.t15 202.036
R87 VDD.n11 VDD.n10 139.249
R88 VDD.n11 VDD.n6 57.0187
R89 VDD.n6 VDD.n5 44.2187
R90 VDD.n5 VDD.n4 44.2187
R91 VDD.n1 VDD.t11 42.2148
R92 VDD.n0 VDD.t19 42.2148
R93 VDD.n0 VDD.t13 42.2148
R94 VDD.n8 VDD.t23 42.2148
R95 VDD.n10 VDD.n9 38.0126
R96 VDD.n4 VDD.n3 38.0126
R97 VDD.n2 VDD.t3 32.8338
R98 VDD.n2 VDD.t5 32.8338
R99 VDD.n1 VDD.t1 32.8338
R100 VDD.n8 VDD.t25 32.8338
R101 VDD.n11 VDD.n7 10.5719
R102 VDD VDD.n11 1.88648
R103 GND.n3 GND.t14 4192.62
R104 GND.t13 GND.t11 3714.75
R105 GND.t8 GND.t6 2200
R106 GND.t11 GND.t9 1027.87
R107 GND.t6 GND.t4 1027.87
R108 GND.t4 GND.t0 1027.87
R109 GND.t0 GND.t2 1027.87
R110 GND.n3 GND.t8 964.755
R111 GND.t14 GND.t13 847.542
R112 GND.n4 GND.t10 207.542
R113 GND.n1 GND.t3 207.542
R114 GND.n5 GND.n4 177.262
R115 GND.n4 GND.t12 163.325
R116 GND.n2 GND.t7 163.325
R117 GND.n1 GND.n0 143.325
R118 GND.n5 GND.n2 57.0187
R119 GND.n2 GND.n1 44.2187
R120 GND.n5 GND.n3 33.4291
R121 GND.n0 GND.t5 20.0005
R122 GND.n0 GND.t1 20.0005
R123 GND GND.n5 1.88648
R124 a_607_84.n9 a_607_84.t3 339.904
R125 a_607_84.n8 a_607_84.n6 307.522
R126 a_607_84.n8 a_607_84.n7 307.072
R127 a_607_84.n0 a_607_84.t10 269.002
R128 a_607_84.n5 a_607_84.t4 255.382
R129 a_607_84.n4 a_607_84.n2 185.915
R130 a_607_84.n3 a_607_84.t8 184.712
R131 a_607_84.n5 a_607_84.n4 171.51
R132 a_607_84.n1 a_607_84.n0 160.667
R133 a_607_84.n2 a_607_84.n1 138.173
R134 a_607_84.n2 a_607_84.t13 130.829
R135 a_607_84.t7 a_607_84.n11 127.072
R136 a_607_84.n10 a_607_84.t6 127.072
R137 a_607_84.n1 a_607_84.t12 96.4005
R138 a_607_84.n0 a_607_84.t11 96.4005
R139 a_607_84.n3 a_607_84.t9 94.7384
R140 a_607_84.n4 a_607_84.n3 84.766
R141 a_607_84.n6 a_607_84.t0 32.8338
R142 a_607_84.n6 a_607_84.t5 32.8338
R143 a_607_84.n7 a_607_84.t2 32.8338
R144 a_607_84.n7 a_607_84.t1 32.8338
R145 a_607_84.n10 a_607_84.n9 10.087
R146 a_607_84.n11 a_607_84.n5 1.08223
R147 a_607_84.n11 a_607_84.n10 0.452423
R148 a_607_84.n9 a_607_84.n8 0.452423
R149 a_178_564.n3 a_178_564.t6 326.534
R150 a_178_564.n6 a_178_564.n5 307.58
R151 a_178_564.n7 a_178_564.n6 307.072
R152 a_178_564.n3 a_178_564.n2 258.392
R153 a_178_564.n1 a_178_564.t10 254.924
R154 a_178_564.n2 a_178_564.t7 234.573
R155 a_178_564.n2 a_178_564.t8 144.601
R156 a_178_564.n4 a_178_564.n0 112.951
R157 a_178_564.n2 a_178_564.n1 110.325
R158 a_178_564.n1 a_178_564.t9 106.547
R159 a_178_564.n5 a_178_564.t2 42.2148
R160 a_178_564.n5 a_178_564.t3 42.2148
R161 a_178_564.n7 a_178_564.t4 32.8338
R162 a_178_564.t5 a_178_564.n7 32.8338
R163 a_178_564.n0 a_178_564.t0 20.0005
R164 a_178_564.n0 a_178_564.t1 20.0005
R165 a_178_564.n4 a_178_564.n3 5.33463
R166 a_178_564.n6 a_178_564.n4 5.188
C10 Q GND 0.83476f
C11 D GND 0.36638f
C12 QB GND 0.82717f
C13 CLK GND 1.08969f
C14 VDD GND 4.60385f
C15 a_178_564.t4 GND 0.02377f ; **FLOATING
C16 a_178_564.t1 GND 0.02377f ; **FLOATING
C17 a_178_564.t0 GND 0.02377f ; **FLOATING
C18 a_178_564.n0 GND 0.06727f ; **FLOATING
C19 a_178_564.t6 GND 0.30244f ; **FLOATING
C20 a_178_564.t9 GND 0.05838f ; **FLOATING
C21 a_178_564.t10 GND 0.08081f ; **FLOATING
C22 a_178_564.n1 GND 0.06749f ; **FLOATING
C23 a_178_564.t7 GND 0.07801f ; **FLOATING
C24 a_178_564.t8 GND 0.06414f ; **FLOATING
C25 a_178_564.n2 GND 0.10743f ; **FLOATING
C26 a_178_564.n3 GND 0.59547f ; **FLOATING
C27 a_178_564.n4 GND 0.52159f ; **FLOATING
C28 a_178_564.t3 GND 0.03056f ; **FLOATING
C29 a_178_564.t2 GND 0.03056f ; **FLOATING
C30 a_178_564.n5 GND 0.06374f ; **FLOATING
C31 a_178_564.n6 GND 0.31637f ; **FLOATING
C32 a_178_564.n7 GND 0.04994f ; **FLOATING
C33 a_178_564.t5 GND 0.02377f ; **FLOATING
C34 a_607_84.t12 GND 0.0687f ; **FLOATING
C35 a_607_84.t11 GND 0.0687f ; **FLOATING
C36 a_607_84.t10 GND 0.09956f ; **FLOATING
C37 a_607_84.n0 GND 0.08262f ; **FLOATING
C38 a_607_84.n1 GND 0.05982f ; **FLOATING
C39 a_607_84.t13 GND 0.07547f ; **FLOATING
C40 a_607_84.n2 GND 0.07711f ; **FLOATING
C41 a_607_84.t8 GND 0.13052f ; **FLOATING
C42 a_607_84.t9 GND 0.10423f ; **FLOATING
C43 a_607_84.n3 GND 0.09399f ; **FLOATING
C44 a_607_84.n4 GND 0.08313f ; **FLOATING
C45 a_607_84.t4 GND 0.04925f ; **FLOATING
C46 a_607_84.n5 GND 0.55542f ; **FLOATING
C47 a_607_84.t5 GND 0.02531f ; **FLOATING
C48 a_607_84.t0 GND 0.02531f ; **FLOATING
C49 a_607_84.n6 GND 0.05336f ; **FLOATING
C50 a_607_84.t1 GND 0.02531f ; **FLOATING
C51 a_607_84.t2 GND 0.02531f ; **FLOATING
C52 a_607_84.n7 GND 0.05316f ; **FLOATING
C53 a_607_84.n8 GND 0.29919f ; **FLOATING
C54 a_607_84.t3 GND 0.09784f ; **FLOATING
C55 a_607_84.n9 GND 0.28447f ; **FLOATING
C56 a_607_84.t6 GND 0.09696f ; **FLOATING
C57 a_607_84.n10 GND 0.28534f ; **FLOATING
C58 a_607_84.n11 GND 0.24897f ; **FLOATING
C59 a_607_84.t7 GND 0.09696f ; **FLOATING
C60 VDD.t9 GND 0.02382f ; **FLOATING
C61 VDD.t13 GND 0.0067f ; **FLOATING
C62 VDD.t19 GND 0.0067f ; **FLOATING
C63 VDD.n0 GND 0.01513f ; **FLOATING
C64 VDD.t1 GND 0.00521f ; **FLOATING
C65 VDD.t11 GND 0.0067f ; **FLOATING
C66 VDD.n1 GND 0.01364f ; **FLOATING
C67 VDD.t5 GND 0.00521f ; **FLOATING
C68 VDD.t3 GND 0.00521f ; **FLOATING
C69 VDD.n2 GND 0.01215f ; **FLOATING
C70 VDD.t7 GND 0.02502f ; **FLOATING
C71 VDD.n3 GND 0.07952f ; **FLOATING
C72 VDD.n4 GND 0.04606f ; **FLOATING
C73 VDD.n5 GND 0.0484f ; **FLOATING
C74 VDD.n6 GND 0.05533f ; **FLOATING
C75 VDD.t6 GND 0.23891f ; **FLOATING
C76 VDD.t4 GND 0.09596f ; **FLOATING
C77 VDD.t2 GND 0.09596f ; **FLOATING
C78 VDD.t0 GND 0.09987f ; **FLOATING
C79 VDD.t10 GND 0.10771f ; **FLOATING
C80 VDD.t12 GND 0.11162f ; **FLOATING
C81 VDD.t18 GND 0.11162f ; **FLOATING
C82 VDD.t8 GND 0.22765f ; **FLOATING
C83 VDD.t20 GND 0.25458f ; **FLOATING
C84 VDD.t22 GND 0.10771f ; **FLOATING
C85 VDD.t24 GND 0.09987f ; **FLOATING
C86 VDD.t26 GND 0.14981f ; **FLOATING
C87 VDD.t17 GND 0.14785f ; **FLOATING
C88 VDD.t16 GND 0.09204f ; **FLOATING
C89 VDD.t15 GND 0.09204f ; **FLOATING
C90 VDD.t14 GND 0.10575f ; **FLOATING
C91 VDD.t28 GND 0.13561f ; **FLOATING
C92 VDD.n7 GND 0.40268f ; **FLOATING
C93 VDD.t27 GND 0.0214f ; **FLOATING
C94 VDD.t25 GND 0.00521f ; **FLOATING
C95 VDD.t23 GND 0.0067f ; **FLOATING
C96 VDD.n8 GND 0.01364f ; **FLOATING
C97 VDD.t21 GND 0.02817f ; **FLOATING
C98 VDD.n9 GND 0.08402f ; **FLOATING
C99 VDD.n10 GND 0.08343f ; **FLOATING
C100 VDD.n11 GND 0.56503f ; **FLOATING
C101 CLK.t4 GND 0.26359f ; **FLOATING
C102 CLK.t0 GND 0.06426f ; **FLOATING
C103 CLK.t1 GND 0.05284f ; **FLOATING
C104 CLK.n0 GND 0.079f ; **FLOATING
C105 CLK.n1 GND 0.31143f ; **FLOATING
C106 CLK.t7 GND 0.05315f ; **FLOATING
C107 CLK.t6 GND 0.05315f ; **FLOATING
C108 CLK.t5 GND 0.07428f ; **FLOATING
C109 CLK.n2 GND 0.06168f ; **FLOATING
C110 CLK.n3 GND 0.04529f ; **FLOATING
C111 CLK.t8 GND 0.0584f ; **FLOATING
C112 CLK.n4 GND 0.05966f ; **FLOATING
C113 CLK.t2 GND 0.10099f ; **FLOATING
C114 CLK.t3 GND 0.08065f ; **FLOATING
C115 CLK.n5 GND 0.07273f ; **FLOATING
C116 CLK.n6 GND 0.05744f ; **FLOATING
C117 QB.t10 GND 0.05741f ; **FLOATING
C118 QB.t9 GND 0.05741f ; **FLOATING
C119 QB.t8 GND 0.08022f ; **FLOATING
C120 QB.n0 GND 0.06554f ; **FLOATING
C121 QB.n1 GND 0.04559f ; **FLOATING
C122 QB.t11 GND 0.06307f ; **FLOATING
C123 QB.n2 GND 0.07296f ; **FLOATING
C124 QB.t3 GND 0.02719f ; **FLOATING
C125 QB.t4 GND 0.02719f ; **FLOATING
C126 QB.n3 GND 0.05881f ; **FLOATING
C127 QB.t5 GND 0.02719f ; **FLOATING
C128 QB.t0 GND 0.02719f ; **FLOATING
C129 QB.n4 GND 0.05881f ; **FLOATING
C130 QB.n5 GND 0.24503f ; **FLOATING
C131 QB.t1 GND 0.02115f ; **FLOATING
C132 QB.t2 GND 0.02115f ; **FLOATING
C133 QB.n6 GND 0.05503f ; **FLOATING
C134 QB.n7 GND 0.39411f ; **FLOATING
C135 QB.t6 GND 0.10907f ; **FLOATING
C136 QB.t7 GND 0.0871f ; **FLOATING
C137 QB.n8 GND 0.11931f ; **FLOATING
C138 QB.n9 GND 0.12261f ; **FLOATING
C139 D.t2 GND 0.03522f ; **FLOATING
C140 D.t3 GND 0.03522f ; **FLOATING
C141 D.n0 GND 0.0778f ; **FLOATING
C142 D.t1 GND 0.03522f ; **FLOATING
C143 D.t0 GND 0.03522f ; **FLOATING
C144 D.n1 GND 0.11842f ; **FLOATING
C145 D.t4 GND 0.03522f ; **FLOATING
C146 D.t5 GND 0.03522f ; **FLOATING
C147 D.n2 GND 0.07767f ; **FLOATING
C148 D.n3 GND 0.7527f ; **FLOATING
C149 Q.t6 GND 0.02623f ; **FLOATING
C150 Q.t0 GND 0.02623f ; **FLOATING
C151 Q.n0 GND 0.05531f ; **FLOATING
C152 Q.t1 GND 0.02623f ; **FLOATING
C153 Q.t4 GND 0.02623f ; **FLOATING
C154 Q.n1 GND 0.0551f ; **FLOATING
C155 Q.n2 GND 0.4275f ; **FLOATING
C156 Q.t5 GND 0.1017f ; **FLOATING
C157 Q.t2 GND 0.02623f ; **FLOATING
C158 Q.t3 GND 0.02623f ; **FLOATING
C159 Q.n3 GND 0.0681f ; **FLOATING
C160 Q.t7 GND 0.04893f ; **FLOATING
C161 Q.n4 GND 0.56367f ; **FLOATING
C162 Q.n5 GND 0.44094f ; **FLOATING
.ends
