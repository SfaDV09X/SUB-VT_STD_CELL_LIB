* NGSPICE file created from maoi4x4.ext - technology: sky130A

.subckt maoi4x4 A VDD GND B Y D C
X0 a_435_564.t0 B.t2 VDD.t35 VDD.t34 sky130_fd_pr__pfet_01v8 ad=0.1344 pd=1.16 as=0.1491 ps=1.195 w=0.84 l=0.21
X1 VDD.t27 a_209_564.t8 a_652_564.t16 VDD.t26 sky130_fd_pr__pfet_01v8 ad=0.1512 pd=1.2 as=0.1512 ps=1.2 w=0.84 l=0.2
X2 a_652_564.t13 D.t5 Y.t17 VDD.t22 sky130_fd_pr__pfet_01v8 ad=0.1512 pd=1.2 as=0.1512 ps=1.2 w=0.84 l=0.2
X3 VDD.t3 A.t1 a_209_564.t1 VDD.t2 sky130_fd_pr__pfet_01v8 ad=0.1491 pd=1.195 as=0.1491 ps=1.195 w=0.84 l=0.21
X4 GND.t20 D.t1 a_1989_84.t6 GND.t19 sky130_fd_pr__nfet_01v8 ad=0.1176 pd=1.12 as=0.1176 ps=1.12 w=0.84 l=0.28
X5 GND.t14 a_435_564.t4 a_981_84.t4 GND.t13 sky130_fd_pr__nfet_01v8 ad=0.1176 pd=1.12 as=0.1176 ps=1.12 w=0.84 l=0.28
X6 GND.t16 D.t3 a_1989_84.t4 GND.t15 sky130_fd_pr__nfet_01v8 ad=0.1176 pd=1.12 as=0.1176 ps=1.12 w=0.84 l=0.28
X7 a_209_564.t0 A.t2 VDD.t1 VDD.t0 sky130_fd_pr__pfet_01v8 ad=0.1491 pd=1.195 as=0.273 ps=2.33 w=0.84 l=0.21
X8 GND.t12 a_435_564.t6 a_981_84.t3 GND.t11 sky130_fd_pr__nfet_01v8 ad=0.1176 pd=1.12 as=0.1176 ps=1.12 w=0.84 l=0.28
X9 a_1989_84.t2 C.t1 Y.t11 GND.t4 sky130_fd_pr__nfet_01v8 ad=0.1176 pd=1.12 as=0.1176 ps=1.12 w=0.84 l=0.28
X10 VDD.t18 a_209_564.t11 a_652_564.t9 VDD.t17 sky130_fd_pr__pfet_01v8 ad=0.1512 pd=1.2 as=0.2394 ps=2.25 w=0.84 l=0.2
X11 a_652_564.t3 C.t5 Y.t9 VDD.t7 sky130_fd_pr__pfet_01v8 ad=0.1512 pd=1.2 as=0.1512 ps=1.2 w=0.84 l=0.2
X12 a_652_564.t1 C.t7 Y.t6 VDD.t5 sky130_fd_pr__pfet_01v8 ad=0.1512 pd=1.2 as=0.1512 ps=1.2 w=0.84 l=0.2
X13 Y.t14 D.t6 a_652_564.t12 VDD.t21 sky130_fd_pr__pfet_01v8 ad=0.1512 pd=1.2 as=0.1512 ps=1.2 w=0.84 l=0.2
X14 a_981_84.t5 a_209_564.t4 Y.t8 GND.t23 sky130_fd_pr__nfet_01v8 ad=0.1176 pd=1.12 as=0.1176 ps=1.12 w=0.84 l=0.28
X15 a_652_564.t17 a_209_564.t9 VDD.t29 VDD.t28 sky130_fd_pr__pfet_01v8 ad=0.1512 pd=1.2 as=0.1512 ps=1.2 w=0.84 l=0.2
X16 Y.t7 C.t6 a_652_564.t2 VDD.t6 sky130_fd_pr__pfet_01v8 ad=0.1512 pd=1.2 as=0.1512 ps=1.2 w=0.84 l=0.2
X17 a_981_84.t0 a_209_564.t6 Y.t2 GND.t6 sky130_fd_pr__nfet_01v8 ad=0.1176 pd=1.12 as=0.2394 ps=2.25 w=0.84 l=0.28
X18 Y.t10 a_209_564.t5 a_981_84.t6 GND.t24 sky130_fd_pr__nfet_01v8 ad=0.1176 pd=1.12 as=0.1176 ps=1.12 w=0.84 l=0.28
X19 VDD.t14 a_435_564.t9 a_652_564.t7 VDD.t13 sky130_fd_pr__pfet_01v8 ad=0.1512 pd=1.2 as=0.1512 ps=1.2 w=0.84 l=0.2
X20 Y.t1 C.t8 a_652_564.t0 VDD.t4 sky130_fd_pr__pfet_01v8 ad=0.1512 pd=1.2 as=0.1512 ps=1.2 w=0.84 l=0.2
X21 a_652_564.t11 D.t7 Y.t15 VDD.t20 sky130_fd_pr__pfet_01v8 ad=0.1512 pd=1.2 as=0.1512 ps=1.2 w=0.84 l=0.2
X22 a_652_564.t14 D.t4 Y.t16 VDD.t23 sky130_fd_pr__pfet_01v8 ad=0.2394 pd=2.25 as=0.1512 ps=1.2 w=0.84 l=0.2
X23 a_652_564.t5 a_435_564.t10 VDD.t10 VDD.t9 sky130_fd_pr__pfet_01v8 ad=0.1512 pd=1.2 as=0.1512 ps=1.2 w=0.84 l=0.2
X24 a_652_564.t19 a_209_564.t7 VDD.t33 VDD.t32 sky130_fd_pr__pfet_01v8 ad=0.1512 pd=1.2 as=0.1512 ps=1.2 w=0.84 l=0.2
X25 Y.t4 C.t0 a_1989_84.t3 GND.t5 sky130_fd_pr__nfet_01v8 ad=0.273 pd=2.33 as=0.1176 ps=1.12 w=0.84 l=0.28
X26 Y.t12 a_209_564.t3 a_981_84.t7 GND.t25 sky130_fd_pr__nfet_01v8 ad=0.2394 pd=2.25 as=0.1176 ps=1.12 w=0.84 l=0.28
X27 VDD.t31 a_209_564.t10 a_652_564.t18 VDD.t30 sky130_fd_pr__pfet_01v8 ad=0.1512 pd=1.2 as=0.1512 ps=1.2 w=0.84 l=0.2
X28 VDD.t37 B.t1 a_435_564.t1 VDD.t36 sky130_fd_pr__pfet_01v8 ad=0.2394 pd=2.25 as=0.1344 ps=1.16 w=0.84 l=0.21
X29 Y.t13 D.t8 a_652_564.t10 VDD.t19 sky130_fd_pr__pfet_01v8 ad=0.1512 pd=1.2 as=0.1512 ps=1.2 w=0.84 l=0.2
X30 Y.t5 C.t2 a_1989_84.t1 GND.t3 sky130_fd_pr__nfet_01v8 ad=0.1176 pd=1.12 as=0.1176 ps=1.12 w=0.84 l=0.28
X31 a_652_564.t15 a_435_564.t8 VDD.t25 VDD.t24 sky130_fd_pr__pfet_01v8 ad=0.1512 pd=1.2 as=0.1512 ps=1.2 w=0.84 l=0.2
X32 Y.t0 C.t4 a_652_564.t4 VDD.t8 sky130_fd_pr__pfet_01v8 ad=0.1512 pd=1.2 as=0.1512 ps=1.2 w=0.84 l=0.2
X33 a_209_564.t2 A.t0 GND.t1 GND.t0 sky130_fd_pr__nfet_01v8 ad=0.2394 pd=2.25 as=0.2394 ps=2.25 w=0.84 l=0.29
X34 a_1989_84.t7 D.t0 GND.t22 GND.t21 sky130_fd_pr__nfet_01v8 ad=0.1176 pd=1.12 as=0.1176 ps=1.12 w=0.84 l=0.28
X35 VDD.t16 a_435_564.t7 a_652_564.t8 VDD.t15 sky130_fd_pr__pfet_01v8 ad=0.1512 pd=1.2 as=0.1512 ps=1.2 w=0.84 l=0.2
X36 a_981_84.t1 a_435_564.t3 GND.t8 GND.t7 sky130_fd_pr__nfet_01v8 ad=0.1176 pd=1.12 as=0.1176 ps=1.12 w=0.84 l=0.28
X37 a_652_564.t6 a_435_564.t11 VDD.t12 VDD.t11 sky130_fd_pr__pfet_01v8 ad=0.1512 pd=1.2 as=0.1512 ps=1.2 w=0.84 l=0.2
X38 a_1989_84.t5 D.t2 GND.t18 GND.t17 sky130_fd_pr__nfet_01v8 ad=0.1176 pd=1.12 as=0.1176 ps=1.12 w=0.84 l=0.28
X39 a_435_564.t2 B.t0 GND.t27 GND.t26 sky130_fd_pr__nfet_01v8 ad=0.2394 pd=2.25 as=0.2394 ps=2.25 w=0.84 l=0.29
X40 a_981_84.t2 a_435_564.t5 GND.t10 GND.t9 sky130_fd_pr__nfet_01v8 ad=0.1176 pd=1.12 as=0.1176 ps=1.12 w=0.84 l=0.28
X41 a_1989_84.t0 C.t3 Y.t3 GND.t2 sky130_fd_pr__nfet_01v8 ad=0.1176 pd=1.12 as=0.2394 ps=2.25 w=0.84 l=0.28
C0 B VDD 0.2186f
C1 C Y 0.44617f
C2 VDD A 0.21135f
C3 D Y 0.17619f
C4 Y VDD 0.21985f
C5 C D 0.81721f
C6 C VDD 0.4619f
C7 D VDD 0.41596f
C8 B A 0.04542f
C9 Y B 0
R0 Y.n4 Y.n2 307.628
R1 Y.n4 Y.n3 307.072
R2 Y.n6 Y.n5 307.072
R3 Y.n8 Y.n7 307.072
R4 Y.n10 Y.n9 307.072
R5 Y.n1 Y.t4 153.458
R6 Y.n12 Y.t2 147.725
R7 Y.n14 Y.t3 146.648
R8 Y.n13 Y.t12 146.648
R9 Y.n1 Y.n0 126.647
R10 Y.n12 Y.n11 126.647
R11 Y.n2 Y.t0 51.5957
R12 Y.n3 Y.t14 42.2148
R13 Y.n3 Y.t17 42.2148
R14 Y.n5 Y.t7 42.2148
R15 Y.n5 Y.t9 42.2148
R16 Y.n7 Y.t13 42.2148
R17 Y.n7 Y.t15 42.2148
R18 Y.n9 Y.t1 42.2148
R19 Y.n9 Y.t6 42.2148
R20 Y.n2 Y.t16 32.8338
R21 Y.n0 Y.t5 20.0005
R22 Y.n0 Y.t11 20.0005
R23 Y.n11 Y.t10 20.0005
R24 Y.n11 Y.t8 20.0005
R25 Y.n14 Y.n10 10.2793
R26 Y.n13 Y.n12 1.07742
R27 Y Y.n14 1.02213
R28 Y.n10 Y.n8 0.538962
R29 Y.n8 Y.n6 0.538962
R30 Y.n6 Y.n4 0.538962
R31 Y.n14 Y.n13 0.269731
R32 Y Y.n1 0.0557885
R33 D.n3 D.t4 489.101
R34 D.n0 D.t5 253.05
R35 D.n4 D.t7 253.05
R36 D.n2 D.n0 194.46
R37 D.n6 D.n4 194.46
R38 D.n1 D.t0 188.095
R39 D.n5 D.t2 188.095
R40 D D.n6 162.188
R41 D.n3 D.n2 161.3
R42 D.n0 D.t6 137.37
R43 D.n4 D.t8 137.37
R44 D.n1 D.t1 98.1219
R45 D.n5 D.t3 98.1219
R46 D.n2 D.n1 88.0759
R47 D.n6 D.n5 88.0759
R48 D D.n3 0.190404
R49 C.n0 C.t0 277.76
R50 C.n2 C.t3 277.76
R51 C.n3 C.t5 253.05
R52 C.n1 C.t8 253.05
R53 C.n0 C.t4 230.594
R54 C.n4 C.t1 188.095
R55 C.n5 C.n4 184.476
R56 C C.n0 162.298
R57 C.n6 C.n2 162.108
R58 C.n6 C.n5 161.3
R59 C.n3 C.t6 137.37
R60 C.n1 C.t7 137.37
R61 C.n4 C.t2 98.1219
R62 C.n5 C.n3 98.0602
R63 C.n2 C.n1 93.2237
R64 C C.n6 0.0798269
R65 B.n1 B.t0 271.313
R66 B.n0 B.t1 233.655
R67 B B.n1 161.356
R68 B.n0 B.t2 130.829
R69 B.n1 B.n0 94.1053
R70 A.n0 A.t1 244.903
R71 A.n1 A.n0 185.915
R72 A.n1 A.t0 179.504
R73 A A.n1 161.356
R74 A.n0 A.t2 130.829
R75 VDD.t17 VDD.t36 449.209
R76 VDD.n7 VDD.t1 429.368
R77 VDD.n8 VDD.t37 376.158
R78 VDD.n13 VDD.n0 374.937
R79 VDD.n12 VDD.n2 343.325
R80 VDD.n11 VDD.n3 343.325
R81 VDD.n10 VDD.n4 343.325
R82 VDD.n9 VDD.n5 343.325
R83 VDD.n7 VDD.n6 343.325
R84 VDD.t2 VDD.t0 242.874
R85 VDD.t34 VDD.t2 242.874
R86 VDD.t11 VDD.t17 240.725
R87 VDD.t30 VDD.t11 240.725
R88 VDD.t9 VDD.t30 240.725
R89 VDD.t13 VDD.t9 240.725
R90 VDD.t28 VDD.t13 240.725
R91 VDD.t26 VDD.t28 240.725
R92 VDD.t24 VDD.t26 240.725
R93 VDD.t15 VDD.t32 240.725
R94 VDD.t32 VDD.t4 240.725
R95 VDD.t4 VDD.t5 240.725
R96 VDD.t5 VDD.t19 240.725
R97 VDD.t19 VDD.t20 240.725
R98 VDD.t20 VDD.t6 240.725
R99 VDD.t6 VDD.t7 240.725
R100 VDD.t7 VDD.t21 240.725
R101 VDD.t21 VDD.t22 240.725
R102 VDD.t22 VDD.t8 240.725
R103 VDD.t8 VDD.t23 240.725
R104 VDD.n1 VDD.t15 229.977
R105 VDD.t36 VDD.t34 227.828
R106 VDD.n5 VDD.t18 51.5957
R107 VDD.n9 VDD.n8 43.4429
R108 VDD.n11 VDD.n10 43.4429
R109 VDD.n12 VDD.n11 43.4429
R110 VDD.n0 VDD.t16 42.2148
R111 VDD.n0 VDD.t33 42.2148
R112 VDD.n2 VDD.t27 42.2148
R113 VDD.n2 VDD.t25 42.2148
R114 VDD.n3 VDD.t14 42.2148
R115 VDD.n3 VDD.t29 42.2148
R116 VDD.n4 VDD.t31 42.2148
R117 VDD.n4 VDD.t10 42.2148
R118 VDD.n6 VDD.t35 42.2148
R119 VDD.n10 VDD.n9 41.8914
R120 VDD.n8 VDD.n7 41.1157
R121 VDD.n6 VDD.t3 41.0422
R122 VDD.n5 VDD.t12 32.8338
R123 VDD.n13 VDD.n12 11.8308
R124 VDD.n1 VDD.t24 10.7471
R125 VDD.n13 VDD.n1 8.60515
R126 VDD VDD.n13 2.19087
R127 GND.t6 GND.t26 4859.84
R128 GND.t26 GND.t0 2037.7
R129 GND.t25 GND.t2 2019.67
R130 GND.t11 GND.t6 1009.84
R131 GND.t9 GND.t11 1009.84
R132 GND.t24 GND.t9 1009.84
R133 GND.t23 GND.t24 1009.84
R134 GND.t13 GND.t23 1009.84
R135 GND.t7 GND.t25 1009.84
R136 GND.t2 GND.t15 1009.84
R137 GND.t15 GND.t17 1009.84
R138 GND.t17 GND.t3 1009.84
R139 GND.t3 GND.t4 1009.84
R140 GND.t4 GND.t19 1009.84
R141 GND.t19 GND.t21 1009.84
R142 GND.t21 GND.t5 1009.84
R143 GND.n5 GND.t7 964.755
R144 GND.n3 GND.n2 230.208
R145 GND.n7 GND.t1 207.155
R146 GND.n7 GND.t27 163.325
R147 GND.n8 GND.n7 148.171
R148 GND.n8 GND.n6 143.325
R149 GND.n4 GND.n0 143.325
R150 GND.n3 GND.n1 143.325
R151 GND.n4 GND.n3 108.606
R152 GND.n9 GND.n8 76.9944
R153 GND.n5 GND.t13 45.0825
R154 GND.n9 GND.n5 27.2098
R155 GND.n6 GND.t12 20.0005
R156 GND.n6 GND.t10 20.0005
R157 GND.n0 GND.t14 20.0005
R158 GND.n0 GND.t8 20.0005
R159 GND.n1 GND.t16 20.0005
R160 GND.n1 GND.t18 20.0005
R161 GND.n2 GND.t20 20.0005
R162 GND.n2 GND.t22 20.0005
R163 GND.n9 GND.n4 9.89141
R164 GND GND.n9 2.19087
R165 a_1989_84.n5 a_1989_84.n4 107.609
R166 a_1989_84.n2 a_1989_84.n0 107.609
R167 a_1989_84.n4 a_1989_84.n3 107.072
R168 a_1989_84.n2 a_1989_84.n1 107.072
R169 a_1989_84.n5 a_1989_84.t7 20.0005
R170 a_1989_84.t3 a_1989_84.n5 20.0005
R171 a_1989_84.n3 a_1989_84.t2 20.0005
R172 a_1989_84.n3 a_1989_84.t6 20.0005
R173 a_1989_84.n1 a_1989_84.t5 20.0005
R174 a_1989_84.n1 a_1989_84.t1 20.0005
R175 a_1989_84.n0 a_1989_84.t0 20.0005
R176 a_1989_84.n0 a_1989_84.t4 20.0005
R177 a_1989_84.n4 a_1989_84.n2 0.538962
R178 a_981_84.n5 a_981_84.n4 107.609
R179 a_981_84.n2 a_981_84.n0 107.609
R180 a_981_84.n2 a_981_84.n1 107.072
R181 a_981_84.n4 a_981_84.n3 107.072
R182 a_981_84.t0 a_981_84.n5 20.0005
R183 a_981_84.n5 a_981_84.t3 20.0005
R184 a_981_84.n0 a_981_84.t1 20.0005
R185 a_981_84.n0 a_981_84.t7 20.0005
R186 a_981_84.n1 a_981_84.t5 20.0005
R187 a_981_84.n1 a_981_84.t4 20.0005
R188 a_981_84.n3 a_981_84.t2 20.0005
R189 a_981_84.n3 a_981_84.t6 20.0005
R190 a_981_84.n4 a_981_84.n2 0.538962
R191 a_652_564.n16 a_652_564.t14 360
R192 a_652_564.n2 a_652_564.t9 340.423
R193 a_652_564.n17 a_652_564.n16 326.647
R194 a_652_564.n15 a_652_564.n14 326.647
R195 a_652_564.n13 a_652_564.n12 326.647
R196 a_652_564.n11 a_652_564.n10 326.647
R197 a_652_564.n9 a_652_564.n0 307.072
R198 a_652_564.n8 a_652_564.n7 307.072
R199 a_652_564.n6 a_652_564.n5 307.072
R200 a_652_564.n4 a_652_564.n3 307.072
R201 a_652_564.n2 a_652_564.n1 307.072
R202 a_652_564.n17 a_652_564.t13 42.2148
R203 a_652_564.t4 a_652_564.n17 42.2148
R204 a_652_564.n0 a_652_564.t19 42.2148
R205 a_652_564.n0 a_652_564.t0 42.2148
R206 a_652_564.n7 a_652_564.t15 42.2148
R207 a_652_564.n7 a_652_564.t8 42.2148
R208 a_652_564.n5 a_652_564.t17 42.2148
R209 a_652_564.n5 a_652_564.t16 42.2148
R210 a_652_564.n3 a_652_564.t5 42.2148
R211 a_652_564.n3 a_652_564.t7 42.2148
R212 a_652_564.n1 a_652_564.t6 42.2148
R213 a_652_564.n1 a_652_564.t18 42.2148
R214 a_652_564.n14 a_652_564.t3 42.2148
R215 a_652_564.n14 a_652_564.t12 42.2148
R216 a_652_564.n12 a_652_564.t11 42.2148
R217 a_652_564.n12 a_652_564.t2 42.2148
R218 a_652_564.n10 a_652_564.t1 42.2148
R219 a_652_564.n10 a_652_564.t10 42.2148
R220 a_652_564.n11 a_652_564.n9 9.73127
R221 a_652_564.n13 a_652_564.n11 0.538962
R222 a_652_564.n15 a_652_564.n13 0.538962
R223 a_652_564.n16 a_652_564.n15 0.538962
R224 a_652_564.n4 a_652_564.n2 0.538962
R225 a_652_564.n6 a_652_564.n4 0.538962
R226 a_652_564.n8 a_652_564.n6 0.538962
R227 a_652_564.n9 a_652_564.n8 0.538962
R228 a_435_564.n7 a_435_564.t11 391.894
R229 a_435_564.n9 a_435_564.n8 332.565
R230 a_435_564.n0 a_435_564.t7 253.05
R231 a_435_564.n3 a_435_564.t9 253.05
R232 a_435_564.n1 a_435_564.t3 188.095
R233 a_435_564.n4 a_435_564.t5 188.095
R234 a_435_564.n2 a_435_564.n1 184.476
R235 a_435_564.n5 a_435_564.n4 184.476
R236 a_435_564.n6 a_435_564.n2 162.377
R237 a_435_564.n6 a_435_564.n5 161.3
R238 a_435_564.n8 a_435_564.t2 152.749
R239 a_435_564.n0 a_435_564.t8 137.37
R240 a_435_564.n3 a_435_564.t10 137.37
R241 a_435_564.n1 a_435_564.t4 98.1219
R242 a_435_564.n4 a_435_564.t6 98.1219
R243 a_435_564.n2 a_435_564.n0 98.0602
R244 a_435_564.n5 a_435_564.n3 98.0602
R245 a_435_564.n9 a_435_564.t0 42.2148
R246 a_435_564.t1 a_435_564.n9 32.8338
R247 a_435_564.n8 a_435_564.n7 4.61588
R248 a_435_564.n7 a_435_564.n6 0.538962
R249 a_209_564.n7 a_209_564.t11 488.293
R250 a_209_564.n0 a_209_564.t7 326.993
R251 a_209_564.n5 a_209_564.t10 326.993
R252 a_209_564.n9 a_209_564.n8 317.158
R253 a_209_564.n1 a_209_564.t8 253.05
R254 a_209_564.n3 a_209_564.n1 194.46
R255 a_209_564.n2 a_209_564.t4 188.095
R256 a_209_564.n0 a_209_564.t3 181.361
R257 a_209_564.n5 a_209_564.t6 181.361
R258 a_209_564.n4 a_209_564.n0 162.377
R259 a_209_564.n4 a_209_564.n3 161.3
R260 a_209_564.n6 a_209_564.n5 161.3
R261 a_209_564.n1 a_209_564.t9 137.37
R262 a_209_564.n8 a_209_564.t2 127.072
R263 a_209_564.n2 a_209_564.t5 98.1219
R264 a_209_564.n3 a_209_564.n2 88.0759
R265 a_209_564.n9 a_209_564.t0 42.2148
R266 a_209_564.t1 a_209_564.n9 41.0422
R267 a_209_564.n8 a_209_564.n7 10.6063
R268 a_209_564.n6 a_209_564.n4 0.808192
R269 a_209_564.n7 a_209_564.n6 0.538962
C10 Y GND 1.67068f
C11 D GND 0.97573f
C12 C GND 0.85997f
C13 B GND 0.26221f
C14 A GND 0.30624f
C15 VDD GND 5.47427f
C16 a_209_564.t0 GND 0.02733f ; **FLOATING
C17 a_209_564.t7 GND 0.08914f ; **FLOATING
C18 a_209_564.t3 GND 0.10564f ; **FLOATING
C19 a_209_564.n0 GND 0.10767f ; **FLOATING
C20 a_209_564.t8 GND 0.07674f ; **FLOATING
C21 a_209_564.t9 GND 0.06038f ; **FLOATING
C22 a_209_564.n1 GND 0.07933f ; **FLOATING
C23 a_209_564.t4 GND 0.1056f ; **FLOATING
C24 a_209_564.t5 GND 0.08453f ; **FLOATING
C25 a_209_564.n2 GND 0.07685f ; **FLOATING
C26 a_209_564.n3 GND 0.06017f ; **FLOATING
C27 a_209_564.n4 GND 0.34188f ; **FLOATING
C28 a_209_564.t10 GND 0.08914f ; **FLOATING
C29 a_209_564.t6 GND 0.10564f ; **FLOATING
C30 a_209_564.n5 GND 0.10675f ; **FLOATING
C31 a_209_564.n6 GND 0.15072f ; **FLOATING
C32 a_209_564.t11 GND 0.11431f ; **FLOATING
C33 a_209_564.n7 GND 0.23514f ; **FLOATING
C34 a_209_564.t2 GND 0.08145f ; **FLOATING
C35 a_209_564.n8 GND 0.65415f ; **FLOATING
C36 a_209_564.n9 GND 0.06251f ; **FLOATING
C37 a_209_564.t1 GND 0.02657f ; **FLOATING
C38 a_435_564.t0 GND 0.03257f ; **FLOATING
C39 a_435_564.t2 GND 0.11535f ; **FLOATING
C40 a_435_564.t7 GND 0.09143f ; **FLOATING
C41 a_435_564.t8 GND 0.07194f ; **FLOATING
C42 a_435_564.n0 GND 0.07769f ; **FLOATING
C43 a_435_564.t3 GND 0.12581f ; **FLOATING
C44 a_435_564.t4 GND 0.10071f ; **FLOATING
C45 a_435_564.n1 GND 0.10848f ; **FLOATING
C46 a_435_564.n2 GND 0.07268f ; **FLOATING
C47 a_435_564.t9 GND 0.09143f ; **FLOATING
C48 a_435_564.t10 GND 0.07194f ; **FLOATING
C49 a_435_564.n3 GND 0.07769f ; **FLOATING
C50 a_435_564.t5 GND 0.12581f ; **FLOATING
C51 a_435_564.t6 GND 0.10071f ; **FLOATING
C52 a_435_564.n4 GND 0.10848f ; **FLOATING
C53 a_435_564.n5 GND 0.07158f ; **FLOATING
C54 a_435_564.n6 GND 0.37596f ; **FLOATING
C55 a_435_564.t11 GND 0.11934f ; **FLOATING
C56 a_435_564.n7 GND 0.17271f ; **FLOATING
C57 a_435_564.n8 GND 0.91827f ; **FLOATING
C58 a_435_564.n9 GND 0.06793f ; **FLOATING
C59 a_435_564.t1 GND 0.02533f ; **FLOATING
C60 a_652_564.t13 GND 0.03926f ; **FLOATING
C61 a_652_564.t14 GND 0.12171f ; **FLOATING
C62 a_652_564.t0 GND 0.03926f ; **FLOATING
C63 a_652_564.t19 GND 0.03926f ; **FLOATING
C64 a_652_564.n0 GND 0.08159f ; **FLOATING
C65 a_652_564.t9 GND 0.11831f ; **FLOATING
C66 a_652_564.t18 GND 0.03926f ; **FLOATING
C67 a_652_564.t6 GND 0.03926f ; **FLOATING
C68 a_652_564.n1 GND 0.08159f ; **FLOATING
C69 a_652_564.n2 GND 0.40135f ; **FLOATING
C70 a_652_564.t7 GND 0.03926f ; **FLOATING
C71 a_652_564.t5 GND 0.03926f ; **FLOATING
C72 a_652_564.n3 GND 0.08159f ; **FLOATING
C73 a_652_564.n4 GND 0.22584f ; **FLOATING
C74 a_652_564.t16 GND 0.03926f ; **FLOATING
C75 a_652_564.t17 GND 0.03926f ; **FLOATING
C76 a_652_564.n5 GND 0.08159f ; **FLOATING
C77 a_652_564.n6 GND 0.22584f ; **FLOATING
C78 a_652_564.t8 GND 0.03926f ; **FLOATING
C79 a_652_564.t15 GND 0.03926f ; **FLOATING
C80 a_652_564.n7 GND 0.08159f ; **FLOATING
C81 a_652_564.n8 GND 0.22584f ; **FLOATING
C82 a_652_564.n9 GND 0.22851f ; **FLOATING
C83 a_652_564.t10 GND 0.03926f ; **FLOATING
C84 a_652_564.t1 GND 0.03926f ; **FLOATING
C85 a_652_564.n10 GND 0.08479f ; **FLOATING
C86 a_652_564.n11 GND 0.36039f ; **FLOATING
C87 a_652_564.t2 GND 0.03926f ; **FLOATING
C88 a_652_564.t11 GND 0.03926f ; **FLOATING
C89 a_652_564.n12 GND 0.08479f ; **FLOATING
C90 a_652_564.n13 GND 0.22264f ; **FLOATING
C91 a_652_564.t12 GND 0.03926f ; **FLOATING
C92 a_652_564.t3 GND 0.03926f ; **FLOATING
C93 a_652_564.n14 GND 0.08479f ; **FLOATING
C94 a_652_564.n15 GND 0.22264f ; **FLOATING
C95 a_652_564.n16 GND 0.39475f ; **FLOATING
C96 a_652_564.n17 GND 0.08479f ; **FLOATING
C97 a_652_564.t4 GND 0.03926f ; **FLOATING
C98 a_981_84.t3 GND 0.02574f ; **FLOATING
C99 a_981_84.t7 GND 0.02574f ; **FLOATING
C100 a_981_84.t1 GND 0.02574f ; **FLOATING
C101 a_981_84.n0 GND 0.05962f ; **FLOATING
C102 a_981_84.t4 GND 0.02574f ; **FLOATING
C103 a_981_84.t5 GND 0.02574f ; **FLOATING
C104 a_981_84.n1 GND 0.05892f ; **FLOATING
C105 a_981_84.n2 GND 0.32489f ; **FLOATING
C106 a_981_84.t6 GND 0.02574f ; **FLOATING
C107 a_981_84.t2 GND 0.02574f ; **FLOATING
C108 a_981_84.n3 GND 0.05892f ; **FLOATING
C109 a_981_84.n4 GND 0.32489f ; **FLOATING
C110 a_981_84.n5 GND 0.05962f ; **FLOATING
C111 a_981_84.t0 GND 0.02574f ; **FLOATING
C112 a_1989_84.t7 GND 0.0254f ; **FLOATING
C113 a_1989_84.t4 GND 0.0254f ; **FLOATING
C114 a_1989_84.t0 GND 0.0254f ; **FLOATING
C115 a_1989_84.n0 GND 0.05882f ; **FLOATING
C116 a_1989_84.t1 GND 0.0254f ; **FLOATING
C117 a_1989_84.t5 GND 0.0254f ; **FLOATING
C118 a_1989_84.n1 GND 0.05812f ; **FLOATING
C119 a_1989_84.n2 GND 0.32052f ; **FLOATING
C120 a_1989_84.t6 GND 0.0254f ; **FLOATING
C121 a_1989_84.t2 GND 0.0254f ; **FLOATING
C122 a_1989_84.n3 GND 0.05812f ; **FLOATING
C123 a_1989_84.n4 GND 0.32052f ; **FLOATING
C124 a_1989_84.n5 GND 0.05882f ; **FLOATING
C125 a_1989_84.t3 GND 0.0254f ; **FLOATING
C126 VDD.t33 GND 0.00738f ; **FLOATING
C127 VDD.t16 GND 0.00738f ; **FLOATING
C128 VDD.n0 GND 0.03701f ; **FLOATING
C129 VDD.t23 GND 0.30313f ; **FLOATING
C130 VDD.t8 GND 0.12082f ; **FLOATING
C131 VDD.t22 GND 0.12082f ; **FLOATING
C132 VDD.t21 GND 0.12082f ; **FLOATING
C133 VDD.t7 GND 0.12082f ; **FLOATING
C134 VDD.t6 GND 0.12082f ; **FLOATING
C135 VDD.t20 GND 0.12082f ; **FLOATING
C136 VDD.t19 GND 0.12082f ; **FLOATING
C137 VDD.t5 GND 0.12082f ; **FLOATING
C138 VDD.t4 GND 0.12082f ; **FLOATING
C139 VDD.t32 GND 0.12082f ; **FLOATING
C140 VDD.t15 GND 0.11812f ; **FLOATING
C141 VDD.t0 GND 0.31337f ; **FLOATING
C142 VDD.t2 GND 0.1219f ; **FLOATING
C143 VDD.t34 GND 0.11812f ; **FLOATING
C144 VDD.t36 GND 0.1699f ; **FLOATING
C145 VDD.t17 GND 0.17314f ; **FLOATING
C146 VDD.t11 GND 0.12082f ; **FLOATING
C147 VDD.t30 GND 0.12082f ; **FLOATING
C148 VDD.t9 GND 0.12082f ; **FLOATING
C149 VDD.t13 GND 0.12082f ; **FLOATING
C150 VDD.t28 GND 0.12082f ; **FLOATING
C151 VDD.t26 GND 0.12082f ; **FLOATING
C152 VDD.t24 GND 0.06311f ; **FLOATING
C153 VDD.n1 GND 0.27019f ; **FLOATING
C154 VDD.t25 GND 0.00738f ; **FLOATING
C155 VDD.t27 GND 0.00738f ; **FLOATING
C156 VDD.n2 GND 0.01667f ; **FLOATING
C157 VDD.t29 GND 0.00738f ; **FLOATING
C158 VDD.t14 GND 0.00738f ; **FLOATING
C159 VDD.n3 GND 0.01667f ; **FLOATING
C160 VDD.t10 GND 0.00738f ; **FLOATING
C161 VDD.t31 GND 0.00738f ; **FLOATING
C162 VDD.n4 GND 0.01667f ; **FLOATING
C163 VDD.t12 GND 0.00574f ; **FLOATING
C164 VDD.t18 GND 0.00902f ; **FLOATING
C165 VDD.n5 GND 0.01667f ; **FLOATING
C166 VDD.t37 GND 0.02358f ; **FLOATING
C167 VDD.t35 GND 0.00738f ; **FLOATING
C168 VDD.t3 GND 0.00718f ; **FLOATING
C169 VDD.n6 GND 0.01647f ; **FLOATING
C170 VDD.t1 GND 0.03149f ; **FLOATING
C171 VDD.n7 GND 0.09807f ; **FLOATING
C172 VDD.n8 GND 0.05342f ; **FLOATING
C173 VDD.n9 GND 0.05203f ; **FLOATING
C174 VDD.n10 GND 0.05203f ; **FLOATING
C175 VDD.n11 GND 0.05268f ; **FLOATING
C176 VDD.n12 GND 0.03955f ; **FLOATING
C177 VDD.n13 GND 0.9259f ; **FLOATING
C178 A.t1 GND 0.05926f ; **FLOATING
C179 A.t2 GND 0.04661f ; **FLOATING
C180 A.n0 GND 0.06035f ; **FLOATING
C181 A.t0 GND 0.08106f ; **FLOATING
C182 A.n1 GND 0.06382f ; **FLOATING
C183 B.t1 GND 0.06804f ; **FLOATING
C184 B.t2 GND 0.05443f ; **FLOATING
C185 B.n0 GND 0.05728f ; **FLOATING
C186 B.t0 GND 0.1104f ; **FLOATING
C187 B.n1 GND 0.07156f ; **FLOATING
C188 C.t4 GND 0.08582f ; **FLOATING
C189 C.t0 GND 0.14147f ; **FLOATING
C190 C.n0 GND 0.11958f ; **FLOATING
C191 C.t8 GND 0.08805f ; **FLOATING
C192 C.t7 GND 0.06928f ; **FLOATING
C193 C.n1 GND 0.07442f ; **FLOATING
C194 C.t3 GND 0.14147f ; **FLOATING
C195 C.n2 GND 0.09491f ; **FLOATING
C196 C.t5 GND 0.08805f ; **FLOATING
C197 C.t6 GND 0.06928f ; **FLOATING
C198 C.n3 GND 0.07482f ; **FLOATING
C199 C.t1 GND 0.12116f ; **FLOATING
C200 C.t2 GND 0.09699f ; **FLOATING
C201 C.n4 GND 0.10447f ; **FLOATING
C202 C.n5 GND 0.06894f ; **FLOATING
C203 C.n6 GND 0.25057f ; **FLOATING
C204 D.t4 GND 0.11861f ; **FLOATING
C205 D.t5 GND 0.07944f ; **FLOATING
C206 D.t6 GND 0.0625f ; **FLOATING
C207 D.n0 GND 0.08211f ; **FLOATING
C208 D.t0 GND 0.10931f ; **FLOATING
C209 D.t1 GND 0.0875f ; **FLOATING
C210 D.n1 GND 0.07955f ; **FLOATING
C211 D.n2 GND 0.06228f ; **FLOATING
C212 D.n3 GND 0.29039f ; **FLOATING
C213 D.t7 GND 0.07944f ; **FLOATING
C214 D.t8 GND 0.0625f ; **FLOATING
C215 D.n4 GND 0.08211f ; **FLOATING
C216 D.t2 GND 0.10931f ; **FLOATING
C217 D.t3 GND 0.0875f ; **FLOATING
C218 D.n5 GND 0.07955f ; **FLOATING
C219 D.n6 GND 0.06296f ; **FLOATING
C220 Y.t4 GND 0.11056f ; **FLOATING
C221 Y.t11 GND 0.02416f ; **FLOATING
C222 Y.t5 GND 0.02416f ; **FLOATING
C223 Y.n0 GND 0.06111f ; **FLOATING
C224 Y.n1 GND 0.37846f ; **FLOATING
C225 Y.t16 GND 0.02416f ; **FLOATING
C226 Y.t0 GND 0.03796f ; **FLOATING
C227 Y.n2 GND 0.0648f ; **FLOATING
C228 Y.t17 GND 0.03106f ; **FLOATING
C229 Y.t14 GND 0.03106f ; **FLOATING
C230 Y.n3 GND 0.06455f ; **FLOATING
C231 Y.n4 GND 0.31861f ; **FLOATING
C232 Y.t9 GND 0.03106f ; **FLOATING
C233 Y.t7 GND 0.03106f ; **FLOATING
C234 Y.n5 GND 0.06455f ; **FLOATING
C235 Y.n6 GND 0.17865f ; **FLOATING
C236 Y.t15 GND 0.03106f ; **FLOATING
C237 Y.t13 GND 0.03106f ; **FLOATING
C238 Y.n7 GND 0.06455f ; **FLOATING
C239 Y.n8 GND 0.17865f ; **FLOATING
C240 Y.t6 GND 0.03106f ; **FLOATING
C241 Y.t1 GND 0.03106f ; **FLOATING
C242 Y.n9 GND 0.06455f ; **FLOATING
C243 Y.n10 GND 0.29508f ; **FLOATING
C244 Y.t2 GND 0.10072f ; **FLOATING
C245 Y.t8 GND 0.02416f ; **FLOATING
C246 Y.t10 GND 0.02416f ; **FLOATING
C247 Y.n11 GND 0.06111f ; **FLOATING
C248 Y.n12 GND 0.48371f ; **FLOATING
C249 Y.t12 GND 0.09929f ; **FLOATING
C250 Y.n13 GND 0.21005f ; **FLOATING
C251 Y.t3 GND 0.09929f ; **FLOATING
C252 Y.n14 GND 0.36306f ; **FLOATING
.ends
