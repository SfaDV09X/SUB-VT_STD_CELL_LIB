** sch_path: /foss/designs/SUB-VT_STD_CELL_LIB/cells/INV1X1/schematic/inv1x1.sch
**.subckt inv1x1 VDD A Y GND
*.ipin A
*.opin Y
*.iopin VDD
*.iopin GND
XM1 Y A GND GND sky130_fd_pr__nfet_01v8 L=0.15 W=0.42 nf=1 ad=0.1218 as=0.1218 pd=1.42 ps=1.42 nrd=0.69047619047619
+ nrs=0.69047619047619 sa=0 sb=0 sd=0 mult=1
XM2 Y A VDD VDD sky130_fd_pr__pfet_01v8 L=0.15 W=1.26 nf=1 ad=0.3654 as=0.3654 pd=3.1 ps=3.1 nrd=0.23015873015873
+ nrs=0.23015873015873 sa=0 sb=0 sd=0 mult=1
**.ends
.end
