** sch_path: /foss/designs/SUB-VT_STD_CELL_LIB/cells/INV1X1/schematic/inv1x1_tb.sch
**.subckt inv1x1_tb Y
*.opin Y
V2 A 0 PULSE(0 1.8 0 0.1p 0.1p 2n 4n)
V1 VDD 0 1.8
x1 VDD A Y 0 inv1x1
**** begin user architecture code

** opencircuitdesign pdks install
.lib /foss/pdks/sky130A/libs.tech/combined/sky130.lib.spice tt

.option savecurrents
.control
save all

dc V2 0 1.8 0.0005

let Vdiff = v(Y) - v(A)
let Vderiv = deriv(v(Y))

meas dc Vth find v(A) when Vdiff=0 cross=1
meas dc Vil find v(A) when Vderiv=-1 cross=1
meas dc Vih find v(A) when Vderiv=-1 cross=2
meas dc Vol find v(Y) when v(A)=Vih
meas dc Voh find v(Y) when v(A)=Vil

let NMh = Voh - Vih
let NMl = Vil - Vol

echo ========== INV1X1 DC ==========
print Vth
print NMh
print NMl

plot v(Y) v(A)

tran 0.02p 4.5n

meas tran Trise TRIG v(Y) VAL=0.18 RISE=1 TARG v(Y) VAL=1.62 RISE=1
meas tran Tfall TRIG v(Y) VAL=1.62 FALL=1 TARG v(Y) VAL=0.18 FALL=1

echo ========== INV1X1 TRAN ==========
print Trise
print Tfall

plot v(Y) v(A)

.endc

**** end user architecture code
**.ends

* expanding   symbol:  /foss/designs/SUB-VT_STD_CELL_LIB/cells/INV1X1/schematic/inv1x1.sym # of pins=4
** sym_path: /foss/designs/SUB-VT_STD_CELL_LIB/cells/INV1X1/schematic/inv1x1.sym
** sch_path: /foss/designs/SUB-VT_STD_CELL_LIB/cells/INV1X1/schematic/inv1x1.sch
.subckt inv1x1 VDD A Y GND
*.ipin A
*.opin Y
*.iopin VDD
*.iopin GND
XM1 Y A GND GND sky130_fd_pr__nfet_01v8 L=0.15 W=0.42 nf=1 ad=0.1218 as=0.1218 pd=1.42 ps=1.42 nrd=0.69047619047619
+ nrs=0.69047619047619 sa=0 sb=0 sd=0 mult=1
XM2 Y A VDD VDD sky130_fd_pr__pfet_01v8 L=0.15 W=1.26 nf=1 ad=0.3654 as=0.3654 pd=3.1 ps=3.1 nrd=0.23015873015873
+ nrs=0.23015873015873 sa=0 sb=0 sd=0 mult=1
.ends

.end
