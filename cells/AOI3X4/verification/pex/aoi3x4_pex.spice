* NGSPICE file created from aoi3x4.ext - technology: sky130A

.subckt aoi3x4 VDD GND A B C Y
X0 a_85_564.t9 C.t5 Y.t11 VDD.t15 sky130_fd_pr__pfet_01v8 ad=0.1176 pd=1.12 as=0.1176 ps=1.12 w=0.84 l=0.2
X1 a_85_564.t3 B.t7 VDD.t7 VDD.t6 sky130_fd_pr__pfet_01v8 ad=0.1428 pd=1.18 as=0.1428 ps=1.18 w=0.84 l=0.2
X2 Y.t6 C.t6 a_85_564.t8 VDD.t14 sky130_fd_pr__pfet_01v8 ad=0.1176 pd=1.12 as=0.1302 ps=1.15 w=0.84 l=0.2
X3 Y.t7 C.t4 a_85_564.t10 VDD.t16 sky130_fd_pr__pfet_01v8 ad=0.1176 pd=1.12 as=0.1176 ps=1.12 w=0.84 l=0.2
X4 a_85_564.t11 C.t3 Y.t13 VDD.t17 sky130_fd_pr__pfet_01v8 ad=0.2394 pd=2.25 as=0.1176 ps=1.12 w=0.84 l=0.2
X5 a_290_84.t7 A.t2 Y.t2 GND.t18 sky130_fd_pr__nfet_01v8 ad=0.1176 pd=1.12 as=0.1176 ps=1.12 w=0.84 l=0.26
X6 GND.t1 B.t2 a_290_84.t2 GND.t0 sky130_fd_pr__nfet_01v8 ad=0.1176 pd=1.12 as=0.1176 ps=1.12 w=0.84 l=0.26
X7 a_290_84.t3 B.t1 GND.t7 GND.t6 sky130_fd_pr__nfet_01v8 ad=0.1176 pd=1.12 as=0.1176 ps=1.12 w=0.84 l=0.26
X8 a_290_84.t1 B.t3 GND.t5 GND.t4 sky130_fd_pr__nfet_01v8 ad=0.1176 pd=1.12 as=0.1176 ps=1.12 w=0.84 l=0.26
X9 Y.t1 A.t3 a_290_84.t6 GND.t17 sky130_fd_pr__nfet_01v8 ad=0.1176 pd=1.12 as=0.1176 ps=1.12 w=0.84 l=0.26
X10 a_290_84.t5 A.t4 Y.t4 GND.t16 sky130_fd_pr__nfet_01v8 ad=0.126 pd=1.14 as=0.2394 ps=2.25 w=0.84 l=0.26
X11 GND.t13 C.t1 Y.t10 GND.t12 sky130_fd_pr__nfet_01v8 ad=0.1176 pd=1.12 as=0.1176 ps=1.12 w=0.84 l=0.26
X12 a_290_84.t9 A.t0 Y.t3 GND.t20 sky130_fd_pr__nfet_01v8 ad=0.1176 pd=1.12 as=0.1176 ps=1.12 w=0.84 l=0.26
X13 GND.t9 B.t0 a_290_84.t4 GND.t8 sky130_fd_pr__nfet_01v8 ad=0.1176 pd=1.12 as=0.1176 ps=1.12 w=0.84 l=0.26
X14 Y.t0 C.t2 GND.t11 GND.t10 sky130_fd_pr__nfet_01v8 ad=0.1176 pd=1.12 as=0.1176 ps=1.12 w=0.84 l=0.26
X15 VDD.t25 A.t6 a_85_564.t16 VDD.t24 sky130_fd_pr__pfet_01v8 ad=0.1428 pd=1.18 as=0.1428 ps=1.18 w=0.84 l=0.2
X16 Y.t8 A.t1 a_290_84.t8 GND.t19 sky130_fd_pr__nfet_01v8 ad=0.1176 pd=1.12 as=0.1176 ps=1.12 w=0.84 l=0.26
X17 VDD.t1 B.t10 a_85_564.t0 VDD.t0 sky130_fd_pr__pfet_01v8 ad=0.1428 pd=1.18 as=0.1512 ps=1.2 w=0.84 l=0.2
X18 a_85_564.t17 A.t5 VDD.t21 VDD.t20 sky130_fd_pr__pfet_01v8 ad=0.1428 pd=1.18 as=0.1428 ps=1.18 w=0.84 l=0.2
X19 GND.t3 B.t4 a_290_84.t0 GND.t2 sky130_fd_pr__nfet_01v8 ad=0.1176 pd=1.12 as=0.126 ps=1.14 w=0.84 l=0.26
X20 a_85_564.t1 B.t9 VDD.t3 VDD.t2 sky130_fd_pr__pfet_01v8 ad=0.1428 pd=1.18 as=0.1428 ps=1.18 w=0.84 l=0.2
X21 VDD.t11 B.t6 a_85_564.t4 VDD.t10 sky130_fd_pr__pfet_01v8 ad=0.1428 pd=1.18 as=0.1428 ps=1.18 w=0.84 l=0.2
X22 VDD.t19 A.t10 a_85_564.t12 VDD.t18 sky130_fd_pr__pfet_01v8 ad=0.1302 pd=1.15 as=0.2394 ps=2.25 w=0.84 l=0.2
X23 a_85_564.t13 A.t9 VDD.t27 VDD.t26 sky130_fd_pr__pfet_01v8 ad=0.1512 pd=1.2 as=0.1302 ps=1.15 w=0.84 l=0.2
X24 VDD.t23 A.t8 a_85_564.t14 VDD.t22 sky130_fd_pr__pfet_01v8 ad=0.1428 pd=1.18 as=0.1428 ps=1.18 w=0.84 l=0.2
X25 a_85_564.t5 B.t5 VDD.t9 VDD.t8 sky130_fd_pr__pfet_01v8 ad=0.1428 pd=1.18 as=0.1428 ps=1.18 w=0.84 l=0.2
X26 Y.t12 C.t0 GND.t15 GND.t14 sky130_fd_pr__nfet_01v8 ad=0.2394 pd=2.25 as=0.1176 ps=1.12 w=0.84 l=0.26
X27 a_85_564.t15 A.t7 VDD.t29 VDD.t28 sky130_fd_pr__pfet_01v8 ad=0.1428 pd=1.18 as=0.1428 ps=1.18 w=0.84 l=0.2
X28 Y.t5 C.t8 a_85_564.t6 VDD.t12 sky130_fd_pr__pfet_01v8 ad=0.1428 pd=1.18 as=0.1428 ps=1.18 w=0.84 l=0.2
X29 VDD.t5 B.t8 a_85_564.t2 VDD.t4 sky130_fd_pr__pfet_01v8 ad=0.1428 pd=1.18 as=0.1428 ps=1.18 w=0.84 l=0.2
X30 a_85_564.t7 C.t7 Y.t9 VDD.t13 sky130_fd_pr__pfet_01v8 ad=0.1302 pd=1.15 as=0.1428 ps=1.18 w=0.84 l=0.2
C0 B A 0.80918f
C1 B VDD 0.64606f
C2 C B 0.06399f
C3 A VDD 0.57849f
C4 C A 0.00769f
C5 C VDD 0.42609f
C6 B Y 0.05991f
C7 A Y 0.13035f
C8 Y VDD 0.43581f
C9 C Y 0.22477f
R0 Y.n2 Y.n0 327.11
R1 Y.n2 Y.n1 326.647
R2 Y.n4 Y.n3 326.647
R3 Y.n9 Y.t4 147.696
R4 Y.n5 Y.t12 146.907
R5 Y.n7 Y.n6 126.647
R6 Y.n11 Y.n10 126.647
R7 Y.n9 Y.n8 126.647
R8 Y.n3 Y.t5 39.8695
R9 Y.n3 Y.t9 39.8695
R10 Y.n0 Y.t7 32.8338
R11 Y.n0 Y.t13 32.8338
R12 Y.n1 Y.t6 32.8338
R13 Y.n1 Y.t11 32.8338
R14 Y.n6 Y.t0 20.0005
R15 Y.n6 Y.t10 20.0005
R16 Y.n10 Y.t8 20.0005
R17 Y.n10 Y.t3 20.0005
R18 Y.n8 Y.t1 20.0005
R19 Y.n8 Y.t2 20.0005
R20 Y.n5 Y.n4 10.4717
R21 Y.n11 Y.n9 1.03896
R22 Y Y.n7 0.575019
R23 Y.n4 Y.n2 0.490885
R24 Y.n7 Y.n5 0.260115
R25 Y Y.n11 0.204827
R26 C.n0 C.t3 248.767
R27 C.n5 C.t0 223.492
R28 C.n5 C.t2 223.492
R29 C.n6 C.n4 194.46
R30 C C.n6 161.356
R31 C.n3 C.n2 142.458
R32 C.n4 C.t8 137.37
R33 C.n2 C.n1 132.819
R34 C.n1 C.n0 132.819
R35 C.n4 C.n3 130.677
R36 C.n3 C.t7 101.221
R37 C.n2 C.t6 101.221
R38 C.n1 C.t5 101.221
R39 C.n0 C.t4 101.221
R40 C.n5 C.t1 77.862
R41 C.n6 C.n5 75.1652
R42 B.n1 B.t0 291.139
R43 B.n0 B.t5 246.624
R44 B.n2 B.t7 246.624
R45 B.n6 B.t9 246.624
R46 B.n3 B.t1 195.643
R47 B.n7 B.t3 195.643
R48 B.n4 B.n3 185.47
R49 B.n8 B.n7 185.47
R50 B.n5 B.n1 162.339
R51 B B.n8 162.284
R52 B.n5 B.n4 161.3
R53 B.n0 B.t6 137.37
R54 B.n2 B.t8 137.37
R55 B.n6 B.t10 137.37
R56 B.n3 B.t2 105.669
R57 B.n7 B.t4 105.669
R58 B.n1 B.n0 98.0602
R59 B.n4 B.n2 98.0602
R60 B.n8 B.n6 98.0602
R61 B B.n5 0.0557885
R62 A.n0 A.t5 246.624
R63 A.n5 A.t7 246.624
R64 A.n3 A.t10 236.983
R65 A.n1 A.t0 195.643
R66 A.n6 A.t2 195.643
R67 A.n2 A.n0 194.46
R68 A.n7 A.n5 194.46
R69 A.n4 A.t4 189.901
R70 A.n4 A.n3 189.624
R71 A A.n2 162.264
R72 A.n8 A.n4 162.089
R73 A.n8 A.n7 161.3
R74 A.n0 A.t6 137.37
R75 A.n5 A.t8 137.37
R76 A.n3 A.t9 137.37
R77 A.n1 A.t1 105.669
R78 A.n6 A.t3 105.669
R79 A.n2 A.n1 89.0691
R80 A.n7 A.n6 89.0691
R81 A A.n8 0.0750192
R82 VDD.n8 VDD.n7 385.99
R83 VDD.n2 VDD.n1 385.214
R84 VDD.n2 VDD.n0 343.325
R85 VDD.n10 VDD.n4 343.325
R86 VDD.n9 VDD.n5 343.325
R87 VDD.n8 VDD.n6 343.325
R88 VDD.t0 VDD.t26 240.725
R89 VDD.t2 VDD.t0 232.127
R90 VDD.t22 VDD.t2 232.127
R91 VDD.t28 VDD.t22 232.127
R92 VDD.t4 VDD.t28 232.127
R93 VDD.t6 VDD.t4 232.127
R94 VDD.t24 VDD.t6 232.127
R95 VDD.t20 VDD.t10 232.127
R96 VDD.t10 VDD.t8 232.127
R97 VDD.t8 VDD.t12 232.127
R98 VDD.t12 VDD.t13 232.127
R99 VDD.t26 VDD.t18 219.232
R100 VDD.t13 VDD.t14 219.232
R101 VDD.t14 VDD.t15 206.335
R102 VDD.t15 VDD.t16 206.335
R103 VDD.t16 VDD.t17 206.335
R104 VDD.n3 VDD.t20 159.05
R105 VDD.n3 VDD.t24 73.0774
R106 VDD.n9 VDD.n8 41.8914
R107 VDD.n10 VDD.n9 41.8914
R108 VDD.n1 VDD.t11 39.8695
R109 VDD.n1 VDD.t9 39.8695
R110 VDD.n0 VDD.t25 39.8695
R111 VDD.n0 VDD.t21 39.8695
R112 VDD.n4 VDD.t5 39.8695
R113 VDD.n4 VDD.t7 39.8695
R114 VDD.n5 VDD.t23 39.8695
R115 VDD.n5 VDD.t29 39.8695
R116 VDD.n6 VDD.t1 39.8695
R117 VDD.n6 VDD.t3 39.8695
R118 VDD.n7 VDD.t27 39.8695
R119 VDD.n11 VDD.n10 38.0126
R120 VDD.n7 VDD.t19 32.8338
R121 VDD.n11 VDD.n3 12.7591
R122 VDD.n11 VDD.n2 3.87929
R123 VDD VDD.n11 1.69723
R124 GND.t2 GND.t16 1009.84
R125 GND.t4 GND.t2 973.771
R126 GND.t17 GND.t4 973.771
R127 GND.t18 GND.t17 973.771
R128 GND.t0 GND.t18 973.771
R129 GND.t6 GND.t0 973.771
R130 GND.t19 GND.t6 973.771
R131 GND.t20 GND.t8 973.771
R132 GND.t8 GND.t10 973.771
R133 GND.t10 GND.t12 973.771
R134 GND.t12 GND.t14 973.771
R135 GND.n3 GND.t20 667.213
R136 GND.n3 GND.t19 306.558
R137 GND.n6 GND.n5 227.106
R138 GND.n2 GND.n1 185.214
R139 GND.n6 GND.n4 143.325
R140 GND.n2 GND.n0 143.325
R141 GND.n7 GND.n2 45.7702
R142 GND.n7 GND.n3 40.3453
R143 GND.n7 GND.n6 38.0126
R144 GND.n5 GND.t3 20.0005
R145 GND.n5 GND.t5 20.0005
R146 GND.n4 GND.t1 20.0005
R147 GND.n4 GND.t7 20.0005
R148 GND.n0 GND.t9 20.0005
R149 GND.n0 GND.t11 20.0005
R150 GND.n1 GND.t13 20.0005
R151 GND.n1 GND.t15 20.0005
R152 GND GND.n7 1.69723
R153 a_290_84.n2 a_290_84.n0 107.591
R154 a_290_84.n7 a_290_84.n6 107.591
R155 a_290_84.n6 a_290_84.n5 107.072
R156 a_290_84.n4 a_290_84.n3 107.072
R157 a_290_84.n2 a_290_84.n1 107.072
R158 a_290_84.n0 a_290_84.t5 22.8576
R159 a_290_84.n7 a_290_84.t9 20.0005
R160 a_290_84.t4 a_290_84.n7 20.0005
R161 a_290_84.n5 a_290_84.t3 20.0005
R162 a_290_84.n5 a_290_84.t8 20.0005
R163 a_290_84.n3 a_290_84.t7 20.0005
R164 a_290_84.n3 a_290_84.t2 20.0005
R165 a_290_84.n1 a_290_84.t1 20.0005
R166 a_290_84.n1 a_290_84.t6 20.0005
R167 a_290_84.n0 a_290_84.t0 20.0005
R168 a_290_84.n4 a_290_84.n2 0.519731
R169 a_290_84.n6 a_290_84.n4 0.519731
R170 a_85_564.n5 a_85_564.t12 340.404
R171 a_85_564.n1 a_85_564.t11 340.365
R172 a_85_564.n15 a_85_564.n14 307.072
R173 a_85_564.n1 a_85_564.n0 307.072
R174 a_85_564.n3 a_85_564.n2 307.072
R175 a_85_564.n13 a_85_564.n12 307.072
R176 a_85_564.n11 a_85_564.n10 307.072
R177 a_85_564.n9 a_85_564.n8 307.072
R178 a_85_564.n7 a_85_564.n6 307.072
R179 a_85_564.n5 a_85_564.n4 307.072
R180 a_85_564.n4 a_85_564.t13 44.56
R181 a_85_564.t5 a_85_564.n15 39.8695
R182 a_85_564.n15 a_85_564.t6 39.8695
R183 a_85_564.n2 a_85_564.t7 39.8695
R184 a_85_564.n12 a_85_564.t17 39.8695
R185 a_85_564.n12 a_85_564.t4 39.8695
R186 a_85_564.n10 a_85_564.t3 39.8695
R187 a_85_564.n10 a_85_564.t16 39.8695
R188 a_85_564.n8 a_85_564.t15 39.8695
R189 a_85_564.n8 a_85_564.t2 39.8695
R190 a_85_564.n6 a_85_564.t1 39.8695
R191 a_85_564.n6 a_85_564.t14 39.8695
R192 a_85_564.n4 a_85_564.t0 39.8695
R193 a_85_564.n0 a_85_564.t9 32.8338
R194 a_85_564.n0 a_85_564.t10 32.8338
R195 a_85_564.n2 a_85_564.t8 32.8338
R196 a_85_564.n7 a_85_564.n5 0.519731
R197 a_85_564.n9 a_85_564.n7 0.519731
R198 a_85_564.n11 a_85_564.n9 0.519731
R199 a_85_564.n13 a_85_564.n11 0.519731
R200 a_85_564.n14 a_85_564.n13 0.519731
R201 a_85_564.n14 a_85_564.n3 0.519731
R202 a_85_564.n3 a_85_564.n1 0.462038
C10 Y GND 1.56792f
C11 C GND 0.56096f
C12 B GND 0.99027f
C13 A GND 0.98393f
C14 VDD GND 3.87314f
C15 a_85_564.t6 GND 0.03116f ; **FLOATING
C16 a_85_564.t11 GND 0.09938f ; **FLOATING
C17 a_85_564.t10 GND 0.02566f ; **FLOATING
C18 a_85_564.t9 GND 0.02566f ; **FLOATING
C19 a_85_564.n0 GND 0.0539f ; **FLOATING
C20 a_85_564.n1 GND 0.31458f ; **FLOATING
C21 a_85_564.t8 GND 0.02566f ; **FLOATING
C22 a_85_564.t7 GND 0.03116f ; **FLOATING
C23 a_85_564.n2 GND 0.05939f ; **FLOATING
C24 a_85_564.n3 GND 0.17842f ; **FLOATING
C25 a_85_564.t12 GND 0.0994f ; **FLOATING
C26 a_85_564.t0 GND 0.03116f ; **FLOATING
C27 a_85_564.t13 GND 0.03482f ; **FLOATING
C28 a_85_564.n4 GND 0.06856f ; **FLOATING
C29 a_85_564.n5 GND 0.33044f ; **FLOATING
C30 a_85_564.t14 GND 0.03116f ; **FLOATING
C31 a_85_564.t1 GND 0.03116f ; **FLOATING
C32 a_85_564.n6 GND 0.06489f ; **FLOATING
C33 a_85_564.n7 GND 0.18522f ; **FLOATING
C34 a_85_564.t2 GND 0.03116f ; **FLOATING
C35 a_85_564.t15 GND 0.03116f ; **FLOATING
C36 a_85_564.n8 GND 0.06489f ; **FLOATING
C37 a_85_564.n9 GND 0.18522f ; **FLOATING
C38 a_85_564.t16 GND 0.03116f ; **FLOATING
C39 a_85_564.t3 GND 0.03116f ; **FLOATING
C40 a_85_564.n10 GND 0.06489f ; **FLOATING
C41 a_85_564.n11 GND 0.18522f ; **FLOATING
C42 a_85_564.t4 GND 0.03116f ; **FLOATING
C43 a_85_564.t17 GND 0.03116f ; **FLOATING
C44 a_85_564.n12 GND 0.06489f ; **FLOATING
C45 a_85_564.n13 GND 0.18522f ; **FLOATING
C46 a_85_564.n14 GND 0.18522f ; **FLOATING
C47 a_85_564.n15 GND 0.06489f ; **FLOATING
C48 a_85_564.t5 GND 0.03116f ; **FLOATING
C49 a_290_84.t9 GND 0.0249f ; **FLOATING
C50 a_290_84.t0 GND 0.0249f ; **FLOATING
C51 a_290_84.t5 GND 0.02845f ; **FLOATING
C52 a_290_84.n0 GND 0.06118f ; **FLOATING
C53 a_290_84.t6 GND 0.0249f ; **FLOATING
C54 a_290_84.t1 GND 0.0249f ; **FLOATING
C55 a_290_84.n1 GND 0.05698f ; **FLOATING
C56 a_290_84.n2 GND 0.30763f ; **FLOATING
C57 a_290_84.t2 GND 0.0249f ; **FLOATING
C58 a_290_84.t7 GND 0.0249f ; **FLOATING
C59 a_290_84.n3 GND 0.05698f ; **FLOATING
C60 a_290_84.n4 GND 0.17505f ; **FLOATING
C61 a_290_84.t8 GND 0.0249f ; **FLOATING
C62 a_290_84.t3 GND 0.0249f ; **FLOATING
C63 a_290_84.n5 GND 0.05698f ; **FLOATING
C64 a_290_84.n6 GND 0.30763f ; **FLOATING
C65 a_290_84.n7 GND 0.05762f ; **FLOATING
C66 a_290_84.t4 GND 0.0249f ; **FLOATING
C67 VDD.t21 GND 0.00673f ; **FLOATING
C68 VDD.t25 GND 0.00673f ; **FLOATING
C69 VDD.n0 GND 0.0153f ; **FLOATING
C70 VDD.t9 GND 0.00673f ; **FLOATING
C71 VDD.t11 GND 0.00673f ; **FLOATING
C72 VDD.n1 GND 0.03205f ; **FLOATING
C73 VDD.n2 GND 0.17165f ; **FLOATING
C74 VDD.t17 GND 0.2665f ; **FLOATING
C75 VDD.t16 GND 0.09994f ; **FLOATING
C76 VDD.t15 GND 0.09994f ; **FLOATING
C77 VDD.t14 GND 0.10306f ; **FLOATING
C78 VDD.t13 GND 0.10931f ; **FLOATING
C79 VDD.t12 GND 0.11243f ; **FLOATING
C80 VDD.t8 GND 0.11243f ; **FLOATING
C81 VDD.t10 GND 0.11243f ; **FLOATING
C82 VDD.t20 GND 0.09473f ; **FLOATING
C83 VDD.t18 GND 0.26962f ; **FLOATING
C84 VDD.t26 GND 0.11139f ; **FLOATING
C85 VDD.t0 GND 0.11451f ; **FLOATING
C86 VDD.t2 GND 0.11243f ; **FLOATING
C87 VDD.t22 GND 0.11243f ; **FLOATING
C88 VDD.t28 GND 0.11243f ; **FLOATING
C89 VDD.t4 GND 0.11243f ; **FLOATING
C90 VDD.t6 GND 0.11243f ; **FLOATING
C91 VDD.t24 GND 0.07391f ; **FLOATING
C92 VDD.n3 GND 0.19582f ; **FLOATING
C93 VDD.t7 GND 0.00673f ; **FLOATING
C94 VDD.t5 GND 0.00673f ; **FLOATING
C95 VDD.n4 GND 0.0153f ; **FLOATING
C96 VDD.t29 GND 0.00673f ; **FLOATING
C97 VDD.t23 GND 0.00673f ; **FLOATING
C98 VDD.n5 GND 0.0153f ; **FLOATING
C99 VDD.t3 GND 0.00673f ; **FLOATING
C100 VDD.t1 GND 0.00673f ; **FLOATING
C101 VDD.n6 GND 0.0153f ; **FLOATING
C102 VDD.t27 GND 0.00673f ; **FLOATING
C103 VDD.t19 GND 0.00554f ; **FLOATING
C104 VDD.n7 GND 0.02066f ; **FLOATING
C105 VDD.n8 GND 0.10258f ; **FLOATING
C106 VDD.n9 GND 0.04959f ; **FLOATING
C107 VDD.n10 GND 0.04804f ; **FLOATING
C108 VDD.n11 GND 0.44407f ; **FLOATING
C109 A.t5 GND 0.07867f ; **FLOATING
C110 A.t6 GND 0.0625f ; **FLOATING
C111 A.n0 GND 0.08176f ; **FLOATING
C112 A.t0 GND 0.10098f ; **FLOATING
C113 A.t1 GND 0.08125f ; **FLOATING
C114 A.n1 GND 0.07613f ; **FLOATING
C115 A.n2 GND 0.06318f ; **FLOATING
C116 A.t10 GND 0.07749f ; **FLOATING
C117 A.t9 GND 0.0625f ; **FLOATING
C118 A.n3 GND 0.08069f ; **FLOATING
C119 A.t4 GND 0.10112f ; **FLOATING
C120 A.n4 GND 0.08878f ; **FLOATING
C121 A.t7 GND 0.07867f ; **FLOATING
C122 A.t8 GND 0.0625f ; **FLOATING
C123 A.n5 GND 0.08176f ; **FLOATING
C124 A.t2 GND 0.10098f ; **FLOATING
C125 A.t3 GND 0.08125f ; **FLOATING
C126 A.n6 GND 0.07613f ; **FLOATING
C127 A.n7 GND 0.06239f ; **FLOATING
C128 A.n8 GND 0.22171f ; **FLOATING
C129 B.t5 GND 0.08043f ; **FLOATING
C130 B.t6 GND 0.0639f ; **FLOATING
C131 B.n0 GND 0.06866f ; **FLOATING
C132 B.t0 GND 0.12201f ; **FLOATING
C133 B.n1 GND 0.08683f ; **FLOATING
C134 B.t7 GND 0.08043f ; **FLOATING
C135 B.t8 GND 0.0639f ; **FLOATING
C136 B.n2 GND 0.06866f ; **FLOATING
C137 B.t1 GND 0.10324f ; **FLOATING
C138 B.t2 GND 0.08307f ; **FLOATING
C139 B.n3 GND 0.09285f ; **FLOATING
C140 B.n4 GND 0.06372f ; **FLOATING
C141 B.n5 GND 0.27608f ; **FLOATING
C142 B.t9 GND 0.08043f ; **FLOATING
C143 B.t10 GND 0.0639f ; **FLOATING
C144 B.n6 GND 0.06866f ; **FLOATING
C145 B.t3 GND 0.10324f ; **FLOATING
C146 B.t4 GND 0.08307f ; **FLOATING
C147 B.n7 GND 0.09285f ; **FLOATING
C148 B.n8 GND 0.06456f ; **FLOATING
C149 C.t7 GND 0.0423f ; **FLOATING
C150 C.t6 GND 0.0423f ; **FLOATING
C151 C.t5 GND 0.0423f ; **FLOATING
C152 C.t4 GND 0.0423f ; **FLOATING
C153 C.t3 GND 0.05884f ; **FLOATING
C154 C.n0 GND 0.04942f ; **FLOATING
C155 C.n1 GND 0.0359f ; **FLOATING
C156 C.n2 GND 0.03653f ; **FLOATING
C157 C.n3 GND 0.0361f ; **FLOATING
C158 C.t8 GND 0.04648f ; **FLOATING
C159 C.n4 GND 0.04736f ; **FLOATING
C160 C.t1 GND 0.05499f ; **FLOATING
C161 C.t0 GND 0.07847f ; **FLOATING
C162 C.t2 GND 0.07847f ; **FLOATING
C163 C.n5 GND 0.08023f ; **FLOATING
C164 C.n6 GND 0.04452f ; **FLOATING
C165 Y.t12 GND 0.09296f ; **FLOATING
C166 Y.t13 GND 0.02257f ; **FLOATING
C167 Y.t7 GND 0.02257f ; **FLOATING
C168 Y.n0 GND 0.04995f ; **FLOATING
C169 Y.t11 GND 0.02257f ; **FLOATING
C170 Y.t6 GND 0.02257f ; **FLOATING
C171 Y.n1 GND 0.04979f ; **FLOATING
C172 Y.n2 GND 0.26814f ; **FLOATING
C173 Y.t9 GND 0.02741f ; **FLOATING
C174 Y.t5 GND 0.02741f ; **FLOATING
C175 Y.n3 GND 0.05946f ; **FLOATING
C176 Y.n4 GND 0.28837f ; **FLOATING
C177 Y.n5 GND 0.3219f ; **FLOATING
C178 Y.t10 GND 0.02257f ; **FLOATING
C179 Y.t0 GND 0.02257f ; **FLOATING
C180 Y.n6 GND 0.05711f ; **FLOATING
C181 Y.n7 GND 0.13206f ; **FLOATING
C182 Y.t4 GND 0.09407f ; **FLOATING
C183 Y.t2 GND 0.02257f ; **FLOATING
C184 Y.t1 GND 0.02257f ; **FLOATING
C185 Y.n8 GND 0.05711f ; **FLOATING
C186 Y.n9 GND 0.44213f ; **FLOATING
C187 Y.t3 GND 0.02257f ; **FLOATING
C188 Y.t8 GND 0.02257f ; **FLOATING
C189 Y.n10 GND 0.05711f ; **FLOATING
C190 Y.n11 GND 0.17449f ; **FLOATING
.ends
