* NGSPICE file created from xnor2x4.ext - technology: sky130A

.subckt xnor2x4 A B Y VDD GND
X0 a_1879_84.t2 a_181_564.t5 GND.t16 GND.t15 sky130_fd_pr__nfet_01v8 ad=0.1176 pd=1.12 as=0.1176 ps=1.12 w=0.84 l=0.29
X1 a_739_84.t5 A.t0 Y.t19 GND.t8 sky130_fd_pr__nfet_01v8 ad=0.1176 pd=1.12 as=0.1176 ps=1.12 w=0.84 l=0.29
X2 a_624_564.t15 B.t6 Y.t8 VDD.t29 sky130_fd_pr__pfet_01v8 ad=0.2814 pd=2.35 as=0.1596 ps=1.22 w=0.84 l=0.19
X3 Y.t18 A.t3 a_739_84.t2 GND.t5 sky130_fd_pr__nfet_01v8 ad=0.1176 pd=1.12 as=0.1176 ps=1.12 w=0.84 l=0.29
X4 a_1879_84.t8 B.t1 Y.t10 GND.t26 sky130_fd_pr__nfet_01v8 ad=0.1176 pd=1.12 as=0.1176 ps=1.12 w=0.84 l=0.29
X5 a_407_564.t1 B.t12 VDD.t24 VDD.t23 sky130_fd_pr__pfet_01v8 ad=0.1344 pd=1.16 as=0.1491 ps=1.195 w=0.84 l=0.21
X6 a_624_564.t3 A.t7 VDD.t1 VDD.t0 sky130_fd_pr__pfet_01v8 ad=0.1596 pd=1.22 as=0.1596 ps=1.22 w=0.84 l=0.19
X7 Y.t3 a_181_564.t10 a_624_564.t8 VDD.t17 sky130_fd_pr__pfet_01v8 ad=0.1596 pd=1.22 as=0.1596 ps=1.22 w=0.84 l=0.19
X8 GND.t29 a_407_564.t7 a_739_84.t7 GND.t28 sky130_fd_pr__nfet_01v8 ad=0.1176 pd=1.12 as=0.1176 ps=1.12 w=0.84 l=0.29
X9 a_1879_84.t0 a_181_564.t7 GND.t12 GND.t11 sky130_fd_pr__nfet_01v8 ad=0.1176 pd=1.12 as=0.1176 ps=1.12 w=0.84 l=0.29
X10 VDD.t5 A.t11 a_181_564.t2 VDD.t4 sky130_fd_pr__pfet_01v8 ad=0.1491 pd=1.195 as=0.1491 ps=1.195 w=0.84 l=0.21
X11 a_624_564.t18 a_407_564.t12 VDD.t35 VDD.t34 sky130_fd_pr__pfet_01v8 ad=0.1596 pd=1.22 as=0.1596 ps=1.22 w=0.84 l=0.19
X12 GND.t10 a_407_564.t5 a_739_84.t6 GND.t9 sky130_fd_pr__nfet_01v8 ad=0.1176 pd=1.12 as=0.1176 ps=1.12 w=0.84 l=0.29
X13 a_1879_84.t3 a_181_564.t3 GND.t18 GND.t17 sky130_fd_pr__nfet_01v8 ad=0.1176 pd=1.12 as=0.1176 ps=1.12 w=0.84 l=0.29
X14 a_181_564.t1 A.t12 VDD.t7 VDD.t6 sky130_fd_pr__pfet_01v8 ad=0.1491 pd=1.195 as=0.273 ps=2.33 w=0.84 l=0.21
X15 GND.t14 a_181_564.t6 a_1879_84.t1 GND.t13 sky130_fd_pr__nfet_01v8 ad=0.1176 pd=1.12 as=0.1176 ps=1.12 w=0.84 l=0.29
X16 VDD.t37 a_407_564.t11 a_624_564.t19 VDD.t36 sky130_fd_pr__pfet_01v8 ad=0.1596 pd=1.22 as=0.1596 ps=1.22 w=0.84 l=0.19
X17 a_739_84.t1 A.t4 Y.t15 GND.t4 sky130_fd_pr__nfet_01v8 ad=0.1176 pd=1.12 as=0.2394 ps=2.25 w=0.84 l=0.29
X18 Y.t13 B.t2 a_1879_84.t7 GND.t25 sky130_fd_pr__nfet_01v8 ad=0.1176 pd=1.12 as=0.1176 ps=1.12 w=0.84 l=0.29
X19 a_407_564.t0 B.t5 GND.t22 GND.t21 sky130_fd_pr__nfet_01v8 ad=0.2394 pd=2.25 as=0.2394 ps=2.25 w=0.84 l=0.29
X20 VDD.t13 A.t6 a_624_564.t4 VDD.t12 sky130_fd_pr__pfet_01v8 ad=0.1596 pd=1.22 as=0.1596 ps=1.22 w=0.84 l=0.19
X21 a_624_564.t13 B.t8 Y.t7 VDD.t27 sky130_fd_pr__pfet_01v8 ad=0.1596 pd=1.22 as=0.1596 ps=1.22 w=0.84 l=0.19
X22 a_624_564.t1 A.t9 VDD.t9 VDD.t8 sky130_fd_pr__pfet_01v8 ad=0.1596 pd=1.22 as=0.1596 ps=1.22 w=0.84 l=0.19
X23 a_624_564.t16 a_407_564.t8 VDD.t31 VDD.t30 sky130_fd_pr__pfet_01v8 ad=0.1596 pd=1.22 as=0.1596 ps=1.22 w=0.84 l=0.19
X24 Y.t6 B.t7 a_624_564.t14 VDD.t28 sky130_fd_pr__pfet_01v8 ad=0.1596 pd=1.22 as=0.1596 ps=1.22 w=0.84 l=0.19
X25 VDD.t11 A.t8 a_624_564.t2 VDD.t10 sky130_fd_pr__pfet_01v8 ad=0.1596 pd=1.22 as=0.1596 ps=1.22 w=0.84 l=0.19
X26 VDD.t3 A.t10 a_624_564.t0 VDD.t2 sky130_fd_pr__pfet_01v8 ad=0.1596 pd=1.22 as=0.2814 ps=2.35 w=0.84 l=0.19
X27 a_181_564.t0 A.t5 GND.t3 GND.t2 sky130_fd_pr__nfet_01v8 ad=0.2394 pd=2.25 as=0.2394 ps=2.25 w=0.84 l=0.29
X28 Y.t16 A.t1 a_739_84.t4 GND.t7 sky130_fd_pr__nfet_01v8 ad=0.1176 pd=1.12 as=0.1176 ps=1.12 w=0.84 l=0.29
X29 Y.t0 a_181_564.t12 a_624_564.t5 VDD.t14 sky130_fd_pr__pfet_01v8 ad=0.1596 pd=1.22 as=0.1596 ps=1.22 w=0.84 l=0.19
X30 a_624_564.t10 a_407_564.t10 VDD.t20 VDD.t19 sky130_fd_pr__pfet_01v8 ad=0.1596 pd=1.22 as=0.1596 ps=1.22 w=0.84 l=0.19
X31 a_624_564.t7 a_181_564.t9 Y.t2 VDD.t16 sky130_fd_pr__pfet_01v8 ad=0.1596 pd=1.22 as=0.1596 ps=1.22 w=0.84 l=0.19
X32 GND.t1 a_407_564.t3 a_739_84.t0 GND.t0 sky130_fd_pr__nfet_01v8 ad=0.1176 pd=1.12 as=0.1176 ps=1.12 w=0.84 l=0.29
X33 Y.t5 B.t9 a_624_564.t12 VDD.t26 sky130_fd_pr__pfet_01v8 ad=0.1596 pd=1.22 as=0.1596 ps=1.22 w=0.84 l=0.19
X34 VDD.t22 B.t11 a_407_564.t2 VDD.t21 sky130_fd_pr__pfet_01v8 ad=0.2394 pd=2.25 as=0.1344 ps=1.16 w=0.84 l=0.21
X35 a_739_84.t9 a_407_564.t6 GND.t33 GND.t32 sky130_fd_pr__nfet_01v8 ad=0.1176 pd=1.12 as=0.1176 ps=1.12 w=0.84 l=0.29
X36 a_739_84.t3 A.t2 Y.t14 GND.t6 sky130_fd_pr__nfet_01v8 ad=0.1176 pd=1.12 as=0.1176 ps=1.12 w=0.84 l=0.29
X37 GND.t20 a_181_564.t4 a_1879_84.t4 GND.t19 sky130_fd_pr__nfet_01v8 ad=0.1176 pd=1.12 as=0.1176 ps=1.12 w=0.84 l=0.29
X38 Y.t12 B.t4 a_1879_84.t5 GND.t23 sky130_fd_pr__nfet_01v8 ad=0.1176 pd=1.12 as=0.1176 ps=1.12 w=0.84 l=0.29
X39 a_624_564.t11 B.t10 Y.t9 VDD.t25 sky130_fd_pr__pfet_01v8 ad=0.1596 pd=1.22 as=0.1596 ps=1.22 w=0.84 l=0.19
X40 Y.t1 a_181_564.t8 a_624_564.t6 VDD.t15 sky130_fd_pr__pfet_01v8 ad=0.1596 pd=1.22 as=0.1596 ps=1.22 w=0.84 l=0.19
X41 a_1879_84.t6 B.t3 Y.t11 GND.t24 sky130_fd_pr__nfet_01v8 ad=0.1176 pd=1.12 as=0.1176 ps=1.12 w=0.84 l=0.29
X42 VDD.t33 a_407_564.t9 a_624_564.t17 VDD.t32 sky130_fd_pr__pfet_01v8 ad=0.1596 pd=1.22 as=0.1596 ps=1.22 w=0.84 l=0.19
X43 a_624_564.t9 a_181_564.t11 Y.t4 VDD.t18 sky130_fd_pr__pfet_01v8 ad=0.1596 pd=1.22 as=0.1596 ps=1.22 w=0.84 l=0.19
X44 a_739_84.t8 a_407_564.t4 GND.t31 GND.t30 sky130_fd_pr__nfet_01v8 ad=0.1176 pd=1.12 as=0.1176 ps=1.12 w=0.84 l=0.29
X45 Y.t17 B.t0 a_1879_84.t9 GND.t27 sky130_fd_pr__nfet_01v8 ad=0.2394 pd=2.25 as=0.1176 ps=1.12 w=0.84 l=0.29
C0 B VDD 0.82818f
C1 Y VDD 0.78523f
C2 B A 0.8371f
C3 Y A 0.11802f
C4 Y B 0.27058f
C5 VDD A 0.7572f
R0 Y.n8 Y.n6 327.195
R1 Y.n8 Y.n7 326.647
R2 Y.n10 Y.n9 326.647
R3 Y.n12 Y.n11 326.647
R4 Y.n14 Y.n13 326.647
R5 Y.n1 Y.t17 147.744
R6 Y.n3 Y.t15 147.744
R7 Y.n1 Y.n0 126.647
R8 Y.n17 Y.n16 126.647
R9 Y.n5 Y.n4 126.647
R10 Y.n3 Y.n2 126.647
R11 Y.n6 Y.t1 44.56
R12 Y.n6 Y.t8 44.56
R13 Y.n7 Y.t6 44.56
R14 Y.n7 Y.t2 44.56
R15 Y.n9 Y.t3 44.56
R16 Y.n9 Y.t7 44.56
R17 Y.n11 Y.t5 44.56
R18 Y.n11 Y.t4 44.56
R19 Y.n13 Y.t0 44.56
R20 Y.n13 Y.t9 44.56
R21 Y.n0 Y.t13 20.0005
R22 Y.n0 Y.t10 20.0005
R23 Y.n16 Y.t12 20.0005
R24 Y.n16 Y.t11 20.0005
R25 Y.n4 Y.t16 20.0005
R26 Y.n4 Y.t19 20.0005
R27 Y.n2 Y.t18 20.0005
R28 Y.n2 Y.t14 20.0005
R29 Y.n15 Y.n14 10.4717
R30 Y.n5 Y.n3 1.09665
R31 Y.n15 Y.n5 0.822615
R32 Y Y.n17 0.630308
R33 Y.n14 Y.n12 0.548577
R34 Y.n12 Y.n10 0.548577
R35 Y.n10 Y.n8 0.548577
R36 Y Y.n1 0.466846
R37 Y.n17 Y.n15 0.274538
R38 B.n0 B.t0 281.67
R39 B.n2 B.t5 271.313
R40 B.n7 B.t7 266.707
R41 B.n3 B.t9 266.707
R42 B.n0 B.t6 241.692
R43 B.n1 B.t11 233.655
R44 B.n9 B.n8 192.24
R45 B.n5 B.n4 192.24
R46 B.n8 B.t1 184.712
R47 B.n4 B.t3 184.712
R48 B.n6 B.n2 183.478
R49 B B.n0 161.63
R50 B.n10 B.n9 161.3
R51 B.n6 B.n5 161.3
R52 B.n7 B.t8 144.601
R53 B.n3 B.t10 144.601
R54 B.n1 B.t12 130.829
R55 B.n9 B.n7 102.401
R56 B.n5 B.n3 102.401
R57 B.n8 B.t2 94.7384
R58 B.n4 B.t4 94.7384
R59 B.n2 B.n1 94.1053
R60 B.n10 B.n6 1.09665
R61 B B.n10 0.767327
R62 A.n9 A.t10 343.166
R63 A.n0 A.t6 266.707
R64 A.n3 A.t8 266.707
R65 A.n10 A.t11 244.903
R66 A.n2 A.n0 203.875
R67 A.n5 A.n3 203.875
R68 A.n11 A.n10 185.915
R69 A.n1 A.t0 184.712
R70 A.n4 A.t2 184.712
R71 A.n9 A.t4 180.196
R72 A.n11 A.t5 179.504
R73 A.n6 A.n2 171.726
R74 A.n6 A.n5 170.63
R75 A.n12 A.n11 162.486
R76 A.n12 A.n9 161.438
R77 A.n0 A.t7 144.601
R78 A.n3 A.t9 144.601
R79 A.n10 A.t12 130.829
R80 A.n1 A.t1 94.7384
R81 A.n4 A.t3 94.7384
R82 A.n2 A.n1 90.7666
R83 A.n5 A.n4 90.7666
R84 A A.n12 4.63752
R85 A A.n8 4.55579
R86 A.n8 A.n6 0.822615
R87 A.n8 A.n7 0.0557885
R88 VDD.t2 VDD.t21 468.553
R89 VDD.n7 VDD.t7 429.368
R90 VDD.n8 VDD.t22 376.158
R91 VDD.n13 VDD.n0 374.548
R92 VDD.n12 VDD.n2 343.325
R93 VDD.n11 VDD.n3 343.325
R94 VDD.n10 VDD.n4 343.325
R95 VDD.n9 VDD.n5 343.325
R96 VDD.n7 VDD.n6 343.325
R97 VDD.t34 VDD.t2 245.024
R98 VDD.t36 VDD.t34 245.024
R99 VDD.t8 VDD.t36 245.024
R100 VDD.t10 VDD.t8 245.024
R101 VDD.t19 VDD.t10 245.024
R102 VDD.t32 VDD.t19 245.024
R103 VDD.t0 VDD.t32 245.024
R104 VDD.t12 VDD.t30 245.024
R105 VDD.t30 VDD.t14 245.024
R106 VDD.t14 VDD.t25 245.024
R107 VDD.t25 VDD.t26 245.024
R108 VDD.t26 VDD.t18 245.024
R109 VDD.t18 VDD.t17 245.024
R110 VDD.t17 VDD.t27 245.024
R111 VDD.t27 VDD.t28 245.024
R112 VDD.t28 VDD.t16 245.024
R113 VDD.t16 VDD.t15 245.024
R114 VDD.t15 VDD.t29 245.024
R115 VDD.t4 VDD.t6 242.874
R116 VDD.t23 VDD.t4 242.874
R117 VDD.t21 VDD.t23 227.828
R118 VDD.n1 VDD.t12 223.53
R119 VDD.n0 VDD.t13 44.56
R120 VDD.n0 VDD.t31 44.56
R121 VDD.n2 VDD.t33 44.56
R122 VDD.n2 VDD.t1 44.56
R123 VDD.n3 VDD.t11 44.56
R124 VDD.n3 VDD.t20 44.56
R125 VDD.n4 VDD.t37 44.56
R126 VDD.n4 VDD.t9 44.56
R127 VDD.n5 VDD.t3 44.56
R128 VDD.n5 VDD.t35 44.56
R129 VDD.n10 VDD.n9 44.2187
R130 VDD.n11 VDD.n10 44.2187
R131 VDD.n12 VDD.n11 44.2187
R132 VDD.n9 VDD.n8 43.8308
R133 VDD.n6 VDD.t24 42.2148
R134 VDD.n8 VDD.n7 41.1157
R135 VDD.n6 VDD.t5 41.0422
R136 VDD.n1 VDD.t0 21.4937
R137 VDD.n13 VDD.n12 12.9944
R138 VDD.n13 VDD.n1 8.60515
R139 VDD VDD.n13 2.19087
R140 GND.t4 GND.t21 2921.31
R141 GND.t21 GND.t2 2037.7
R142 GND.t28 GND.t4 1027.87
R143 GND.t32 GND.t28 1027.87
R144 GND.t5 GND.t32 1027.87
R145 GND.t6 GND.t5 1027.87
R146 GND.t9 GND.t6 1027.87
R147 GND.t30 GND.t9 1027.87
R148 GND.t7 GND.t30 1027.87
R149 GND.t8 GND.t0 1027.87
R150 GND.t0 GND.t11 1027.87
R151 GND.t11 GND.t23 1027.87
R152 GND.t23 GND.t24 1027.87
R153 GND.t24 GND.t13 1027.87
R154 GND.t13 GND.t15 1027.87
R155 GND.t15 GND.t25 1027.87
R156 GND.t25 GND.t26 1027.87
R157 GND.t26 GND.t19 1027.87
R158 GND.t19 GND.t17 1027.87
R159 GND.t17 GND.t27 1027.87
R160 GND.n5 GND.t8 937.706
R161 GND.n3 GND.n2 231.761
R162 GND.n8 GND.t3 207.155
R163 GND.n8 GND.t22 163.325
R164 GND.n9 GND.n7 143.325
R165 GND.n10 GND.n6 143.325
R166 GND.n4 GND.n0 143.325
R167 GND.n3 GND.n1 143.325
R168 GND.n9 GND.n8 107.055
R169 GND.n5 GND.t7 90.1644
R170 GND.n10 GND.n9 88.4369
R171 GND.n4 GND.n3 88.4369
R172 GND.n11 GND.n4 53.3338
R173 GND.n11 GND.n10 35.1035
R174 GND.n11 GND.n5 27.2098
R175 GND.n7 GND.t29 20.0005
R176 GND.n7 GND.t33 20.0005
R177 GND.n6 GND.t10 20.0005
R178 GND.n6 GND.t31 20.0005
R179 GND.n0 GND.t1 20.0005
R180 GND.n0 GND.t12 20.0005
R181 GND.n1 GND.t14 20.0005
R182 GND.n1 GND.t16 20.0005
R183 GND.n2 GND.t20 20.0005
R184 GND.n2 GND.t18 20.0005
R185 GND GND.n11 2.19087
R186 a_1879_84.n6 a_1879_84.n0 107.62
R187 a_1879_84.n3 a_1879_84.n1 107.62
R188 a_1879_84.n7 a_1879_84.n6 107.072
R189 a_1879_84.n5 a_1879_84.n4 107.072
R190 a_1879_84.n3 a_1879_84.n2 107.072
R191 a_1879_84.t8 a_1879_84.n7 20.0005
R192 a_1879_84.n7 a_1879_84.t4 20.0005
R193 a_1879_84.n0 a_1879_84.t3 20.0005
R194 a_1879_84.n0 a_1879_84.t9 20.0005
R195 a_1879_84.n4 a_1879_84.t2 20.0005
R196 a_1879_84.n4 a_1879_84.t7 20.0005
R197 a_1879_84.n2 a_1879_84.t6 20.0005
R198 a_1879_84.n2 a_1879_84.t1 20.0005
R199 a_1879_84.n1 a_1879_84.t0 20.0005
R200 a_1879_84.n1 a_1879_84.t5 20.0005
R201 a_1879_84.n5 a_1879_84.n3 0.548577
R202 a_1879_84.n6 a_1879_84.n5 0.548577
R203 a_739_84.n7 a_739_84.n6 107.62
R204 a_739_84.n2 a_739_84.n0 107.62
R205 a_739_84.n6 a_739_84.n5 107.072
R206 a_739_84.n4 a_739_84.n3 107.072
R207 a_739_84.n2 a_739_84.n1 107.072
R208 a_739_84.t5 a_739_84.n7 20.0005
R209 a_739_84.n7 a_739_84.t0 20.0005
R210 a_739_84.n5 a_739_84.t8 20.0005
R211 a_739_84.n5 a_739_84.t4 20.0005
R212 a_739_84.n3 a_739_84.t3 20.0005
R213 a_739_84.n3 a_739_84.t6 20.0005
R214 a_739_84.n1 a_739_84.t9 20.0005
R215 a_739_84.n1 a_739_84.t2 20.0005
R216 a_739_84.n0 a_739_84.t1 20.0005
R217 a_739_84.n0 a_739_84.t7 20.0005
R218 a_739_84.n4 a_739_84.n2 0.548577
R219 a_739_84.n6 a_739_84.n4 0.548577
R220 a_624_564.n1 a_624_564.t15 352.178
R221 a_624_564.n11 a_624_564.t0 352.178
R222 a_624_564.n17 a_624_564.n16 307.072
R223 a_624_564.n1 a_624_564.n0 307.072
R224 a_624_564.n3 a_624_564.n2 307.072
R225 a_624_564.n5 a_624_564.n4 307.072
R226 a_624_564.n7 a_624_564.n6 307.072
R227 a_624_564.n9 a_624_564.n8 307.072
R228 a_624_564.n15 a_624_564.n14 307.072
R229 a_624_564.n13 a_624_564.n12 307.072
R230 a_624_564.n11 a_624_564.n10 307.072
R231 a_624_564.n17 a_624_564.t3 44.56
R232 a_624_564.t4 a_624_564.n17 44.56
R233 a_624_564.n0 a_624_564.t7 44.56
R234 a_624_564.n0 a_624_564.t6 44.56
R235 a_624_564.n2 a_624_564.t13 44.56
R236 a_624_564.n2 a_624_564.t14 44.56
R237 a_624_564.n4 a_624_564.t9 44.56
R238 a_624_564.n4 a_624_564.t8 44.56
R239 a_624_564.n6 a_624_564.t11 44.56
R240 a_624_564.n6 a_624_564.t12 44.56
R241 a_624_564.n8 a_624_564.t16 44.56
R242 a_624_564.n8 a_624_564.t5 44.56
R243 a_624_564.n14 a_624_564.t10 44.56
R244 a_624_564.n14 a_624_564.t17 44.56
R245 a_624_564.n12 a_624_564.t1 44.56
R246 a_624_564.n12 a_624_564.t2 44.56
R247 a_624_564.n10 a_624_564.t18 44.56
R248 a_624_564.n10 a_624_564.t19 44.56
R249 a_624_564.n13 a_624_564.n11 0.548577
R250 a_624_564.n15 a_624_564.n13 0.548577
R251 a_624_564.n16 a_624_564.n15 0.548577
R252 a_624_564.n16 a_624_564.n9 0.548577
R253 a_624_564.n9 a_624_564.n7 0.548577
R254 a_624_564.n7 a_624_564.n5 0.548577
R255 a_624_564.n5 a_624_564.n3 0.548577
R256 a_624_564.n3 a_624_564.n1 0.548577
R257 a_181_564.n7 a_181_564.t12 343.166
R258 a_181_564.n10 a_181_564.n9 317.158
R259 a_181_564.n0 a_181_564.t8 266.707
R260 a_181_564.n3 a_181_564.t10 266.707
R261 a_181_564.n2 a_181_564.n0 203.875
R262 a_181_564.n5 a_181_564.n3 203.875
R263 a_181_564.n1 a_181_564.t3 184.712
R264 a_181_564.n4 a_181_564.t5 184.712
R265 a_181_564.n7 a_181_564.t7 180.196
R266 a_181_564.n6 a_181_564.n2 162.397
R267 a_181_564.n8 a_181_564.n7 161.712
R268 a_181_564.n6 a_181_564.n5 161.3
R269 a_181_564.n0 a_181_564.t9 144.601
R270 a_181_564.n3 a_181_564.t11 144.601
R271 a_181_564.n9 a_181_564.t0 127.072
R272 a_181_564.n1 a_181_564.t4 94.7384
R273 a_181_564.n4 a_181_564.t6 94.7384
R274 a_181_564.n2 a_181_564.n1 90.7666
R275 a_181_564.n5 a_181_564.n4 90.7666
R276 a_181_564.n10 a_181_564.t1 42.2148
R277 a_181_564.t2 a_181_564.n10 41.0422
R278 a_181_564.n9 a_181_564.n8 22.7793
R279 a_181_564.n8 a_181_564.n6 0.411558
R280 a_407_564.n0 a_407_564.t8 343.166
R281 a_407_564.n10 a_407_564.n9 326.884
R282 a_407_564.n1 a_407_564.t9 266.707
R283 a_407_564.n5 a_407_564.t11 266.707
R284 a_407_564.n3 a_407_564.n1 203.875
R285 a_407_564.n7 a_407_564.n5 203.875
R286 a_407_564.n2 a_407_564.t4 184.712
R287 a_407_564.n6 a_407_564.t6 184.712
R288 a_407_564.n0 a_407_564.t3 180.196
R289 a_407_564.n4 a_407_564.n0 172.096
R290 a_407_564.n4 a_407_564.n3 171.274
R291 a_407_564.n8 a_407_564.n7 171.274
R292 a_407_564.n9 a_407_564.t0 157.355
R293 a_407_564.n1 a_407_564.t10 144.601
R294 a_407_564.n5 a_407_564.t12 144.601
R295 a_407_564.n2 a_407_564.t5 94.7384
R296 a_407_564.n6 a_407_564.t7 94.7384
R297 a_407_564.n3 a_407_564.n2 90.7666
R298 a_407_564.n7 a_407_564.n6 90.7666
R299 a_407_564.n10 a_407_564.t1 42.2148
R300 a_407_564.t2 a_407_564.n10 32.8338
R301 a_407_564.n8 a_407_564.n4 1.09665
R302 a_407_564.n9 a_407_564.n8 0.817808
C6 Y GND 1.88776f
C7 B GND 1.22073f
C8 A GND 1.13543f
C9 VDD GND 5.49642f
C10 a_407_564.t1 GND 0.04074f ; **FLOATING
C11 a_407_564.t8 GND 0.12604f ; **FLOATING
C12 a_407_564.t3 GND 0.16363f ; **FLOATING
C13 a_407_564.n0 GND 0.17262f ; **FLOATING
C14 a_407_564.t9 GND 0.10941f ; **FLOATING
C15 a_407_564.t10 GND 0.0855f ; **FLOATING
C16 a_407_564.n1 GND 0.11454f ; **FLOATING
C17 a_407_564.t4 GND 0.16342f ; **FLOATING
C18 a_407_564.t5 GND 0.1305f ; **FLOATING
C19 a_407_564.n2 GND 0.11629f ; **FLOATING
C20 a_407_564.n3 GND 0.10258f ; **FLOATING
C21 a_407_564.n4 GND 1.19339f ; **FLOATING
C22 a_407_564.t11 GND 0.10941f ; **FLOATING
C23 a_407_564.t12 GND 0.0855f ; **FLOATING
C24 a_407_564.n5 GND 0.11454f ; **FLOATING
C25 a_407_564.t6 GND 0.16342f ; **FLOATING
C26 a_407_564.t7 GND 0.1305f ; **FLOATING
C27 a_407_564.n6 GND 0.11629f ; **FLOATING
C28 a_407_564.n7 GND 0.10258f ; **FLOATING
C29 a_407_564.n8 GND 0.66592f ; **FLOATING
C30 a_407_564.t0 GND 0.15905f ; **FLOATING
C31 a_407_564.n9 GND 0.92192f ; **FLOATING
C32 a_407_564.n10 GND 0.07904f ; **FLOATING
C33 a_407_564.t2 GND 0.03169f ; **FLOATING
C34 a_181_564.t1 GND 0.0343f ; **FLOATING
C35 a_181_564.t8 GND 0.09212f ; **FLOATING
C36 a_181_564.t9 GND 0.07199f ; **FLOATING
C37 a_181_564.n0 GND 0.09644f ; **FLOATING
C38 a_181_564.t3 GND 0.13759f ; **FLOATING
C39 a_181_564.t4 GND 0.10988f ; **FLOATING
C40 a_181_564.n1 GND 0.09791f ; **FLOATING
C41 a_181_564.n2 GND 0.07506f ; **FLOATING
C42 a_181_564.t10 GND 0.09212f ; **FLOATING
C43 a_181_564.t11 GND 0.07199f ; **FLOATING
C44 a_181_564.n3 GND 0.09644f ; **FLOATING
C45 a_181_564.t5 GND 0.13759f ; **FLOATING
C46 a_181_564.t6 GND 0.10988f ; **FLOATING
C47 a_181_564.n4 GND 0.09791f ; **FLOATING
C48 a_181_564.n5 GND 0.07386f ; **FLOATING
C49 a_181_564.n6 GND 0.38507f ; **FLOATING
C50 a_181_564.t12 GND 0.10612f ; **FLOATING
C51 a_181_564.t7 GND 0.13776f ; **FLOATING
C52 a_181_564.n7 GND 0.13094f ; **FLOATING
C53 a_181_564.n8 GND 0.74146f ; **FLOATING
C54 a_181_564.t0 GND 0.10222f ; **FLOATING
C55 a_181_564.n9 GND 1.24966f ; **FLOATING
C56 a_181_564.n10 GND 0.07845f ; **FLOATING
C57 a_181_564.t2 GND 0.03335f ; **FLOATING
C58 a_624_564.t3 GND 0.04329f ; **FLOATING
C59 a_624_564.t15 GND 0.14189f ; **FLOATING
C60 a_624_564.t6 GND 0.04329f ; **FLOATING
C61 a_624_564.t7 GND 0.04329f ; **FLOATING
C62 a_624_564.n0 GND 0.08978f ; **FLOATING
C63 a_624_564.n1 GND 0.43356f ; **FLOATING
C64 a_624_564.t14 GND 0.04329f ; **FLOATING
C65 a_624_564.t13 GND 0.04329f ; **FLOATING
C66 a_624_564.n2 GND 0.08978f ; **FLOATING
C67 a_624_564.n3 GND 0.23871f ; **FLOATING
C68 a_624_564.t8 GND 0.04329f ; **FLOATING
C69 a_624_564.t9 GND 0.04329f ; **FLOATING
C70 a_624_564.n4 GND 0.08978f ; **FLOATING
C71 a_624_564.n5 GND 0.23871f ; **FLOATING
C72 a_624_564.t12 GND 0.04329f ; **FLOATING
C73 a_624_564.t11 GND 0.04329f ; **FLOATING
C74 a_624_564.n6 GND 0.08978f ; **FLOATING
C75 a_624_564.n7 GND 0.23871f ; **FLOATING
C76 a_624_564.t5 GND 0.04329f ; **FLOATING
C77 a_624_564.t16 GND 0.04329f ; **FLOATING
C78 a_624_564.n8 GND 0.08978f ; **FLOATING
C79 a_624_564.n9 GND 0.23871f ; **FLOATING
C80 a_624_564.t0 GND 0.14189f ; **FLOATING
C81 a_624_564.t19 GND 0.04329f ; **FLOATING
C82 a_624_564.t18 GND 0.04329f ; **FLOATING
C83 a_624_564.n10 GND 0.08978f ; **FLOATING
C84 a_624_564.n11 GND 0.43356f ; **FLOATING
C85 a_624_564.t2 GND 0.04329f ; **FLOATING
C86 a_624_564.t1 GND 0.04329f ; **FLOATING
C87 a_624_564.n12 GND 0.08978f ; **FLOATING
C88 a_624_564.n13 GND 0.23871f ; **FLOATING
C89 a_624_564.t17 GND 0.04329f ; **FLOATING
C90 a_624_564.t10 GND 0.04329f ; **FLOATING
C91 a_624_564.n14 GND 0.08978f ; **FLOATING
C92 a_624_564.n15 GND 0.23871f ; **FLOATING
C93 a_624_564.n16 GND 0.23871f ; **FLOATING
C94 a_624_564.n17 GND 0.08978f ; **FLOATING
C95 a_624_564.t4 GND 0.04329f ; **FLOATING
C96 a_739_84.t0 GND 0.03278f ; **FLOATING
C97 a_739_84.t7 GND 0.03278f ; **FLOATING
C98 a_739_84.t1 GND 0.03278f ; **FLOATING
C99 a_739_84.n0 GND 0.07594f ; **FLOATING
C100 a_739_84.t2 GND 0.03278f ; **FLOATING
C101 a_739_84.t9 GND 0.03278f ; **FLOATING
C102 a_739_84.n1 GND 0.07503f ; **FLOATING
C103 a_739_84.n2 GND 0.41804f ; **FLOATING
C104 a_739_84.t6 GND 0.03278f ; **FLOATING
C105 a_739_84.t3 GND 0.03278f ; **FLOATING
C106 a_739_84.n3 GND 0.07503f ; **FLOATING
C107 a_739_84.n4 GND 0.2392f ; **FLOATING
C108 a_739_84.t4 GND 0.03278f ; **FLOATING
C109 a_739_84.t8 GND 0.03278f ; **FLOATING
C110 a_739_84.n5 GND 0.07503f ; **FLOATING
C111 a_739_84.n6 GND 0.41804f ; **FLOATING
C112 a_739_84.n7 GND 0.07594f ; **FLOATING
C113 a_739_84.t5 GND 0.03278f ; **FLOATING
C114 a_1879_84.t4 GND 0.02744f ; **FLOATING
C115 a_1879_84.t9 GND 0.02744f ; **FLOATING
C116 a_1879_84.t3 GND 0.02744f ; **FLOATING
C117 a_1879_84.n0 GND 0.06357f ; **FLOATING
C118 a_1879_84.t5 GND 0.02744f ; **FLOATING
C119 a_1879_84.t0 GND 0.02744f ; **FLOATING
C120 a_1879_84.n1 GND 0.06357f ; **FLOATING
C121 a_1879_84.t1 GND 0.02744f ; **FLOATING
C122 a_1879_84.t6 GND 0.02744f ; **FLOATING
C123 a_1879_84.n2 GND 0.06281f ; **FLOATING
C124 a_1879_84.n3 GND 0.34996f ; **FLOATING
C125 a_1879_84.t7 GND 0.02744f ; **FLOATING
C126 a_1879_84.t2 GND 0.02744f ; **FLOATING
C127 a_1879_84.n4 GND 0.06281f ; **FLOATING
C128 a_1879_84.n5 GND 0.20024f ; **FLOATING
C129 a_1879_84.n6 GND 0.34996f ; **FLOATING
C130 a_1879_84.n7 GND 0.06281f ; **FLOATING
C131 a_1879_84.t8 GND 0.02744f ; **FLOATING
C132 VDD.t31 GND 0.00834f ; **FLOATING
C133 VDD.t13 GND 0.00834f ; **FLOATING
C134 VDD.n0 GND 0.04026f ; **FLOATING
C135 VDD.t29 GND 0.30371f ; **FLOATING
C136 VDD.t15 GND 0.13164f ; **FLOATING
C137 VDD.t16 GND 0.13164f ; **FLOATING
C138 VDD.t28 GND 0.13164f ; **FLOATING
C139 VDD.t27 GND 0.13164f ; **FLOATING
C140 VDD.t17 GND 0.13164f ; **FLOATING
C141 VDD.t18 GND 0.13164f ; **FLOATING
C142 VDD.t26 GND 0.13164f ; **FLOATING
C143 VDD.t25 GND 0.13164f ; **FLOATING
C144 VDD.t14 GND 0.13164f ; **FLOATING
C145 VDD.t30 GND 0.13164f ; **FLOATING
C146 VDD.t12 GND 0.12587f ; **FLOATING
C147 VDD.t6 GND 0.30313f ; **FLOATING
C148 VDD.t4 GND 0.13049f ; **FLOATING
C149 VDD.t23 GND 0.12645f ; **FLOATING
C150 VDD.t21 GND 0.18707f ; **FLOATING
C151 VDD.t2 GND 0.19169f ; **FLOATING
C152 VDD.t34 GND 0.13164f ; **FLOATING
C153 VDD.t36 GND 0.13164f ; **FLOATING
C154 VDD.t8 GND 0.13164f ; **FLOATING
C155 VDD.t10 GND 0.13164f ; **FLOATING
C156 VDD.t19 GND 0.13164f ; **FLOATING
C157 VDD.t32 GND 0.13164f ; **FLOATING
C158 VDD.t0 GND 0.0716f ; **FLOATING
C159 VDD.n1 GND 0.29039f ; **FLOATING
C160 VDD.t1 GND 0.00834f ; **FLOATING
C161 VDD.t33 GND 0.00834f ; **FLOATING
C162 VDD.n2 GND 0.01872f ; **FLOATING
C163 VDD.t20 GND 0.00834f ; **FLOATING
C164 VDD.t11 GND 0.00834f ; **FLOATING
C165 VDD.n3 GND 0.01872f ; **FLOATING
C166 VDD.t9 GND 0.00834f ; **FLOATING
C167 VDD.t37 GND 0.00834f ; **FLOATING
C168 VDD.n4 GND 0.01872f ; **FLOATING
C169 VDD.t35 GND 0.00834f ; **FLOATING
C170 VDD.t3 GND 0.00834f ; **FLOATING
C171 VDD.n5 GND 0.01872f ; **FLOATING
C172 VDD.t22 GND 0.02524f ; **FLOATING
C173 VDD.t24 GND 0.0079f ; **FLOATING
C174 VDD.t5 GND 0.00768f ; **FLOATING
C175 VDD.n6 GND 0.01763f ; **FLOATING
C176 VDD.t7 GND 0.03322f ; **FLOATING
C177 VDD.n7 GND 0.10065f ; **FLOATING
C178 VDD.n8 GND 0.05735f ; **FLOATING
C179 VDD.n9 GND 0.05691f ; **FLOATING
C180 VDD.n10 GND 0.05708f ; **FLOATING
C181 VDD.n11 GND 0.05708f ; **FLOATING
C182 VDD.n12 GND 0.0432f ; **FLOATING
C183 VDD.n13 GND 0.99192f ; **FLOATING
C184 A.t6 GND 0.08894f ; **FLOATING
C185 A.t7 GND 0.06951f ; **FLOATING
C186 A.n0 GND 0.09312f ; **FLOATING
C187 A.t0 GND 0.13285f ; **FLOATING
C188 A.t1 GND 0.10609f ; **FLOATING
C189 A.n1 GND 0.09453f ; **FLOATING
C190 A.n2 GND 0.08054f ; **FLOATING
C191 A.t8 GND 0.08894f ; **FLOATING
C192 A.t9 GND 0.06951f ; **FLOATING
C193 A.n3 GND 0.09312f ; **FLOATING
C194 A.t2 GND 0.13285f ; **FLOATING
C195 A.t3 GND 0.10609f ; **FLOATING
C196 A.n4 GND 0.09453f ; **FLOATING
C197 A.n5 GND 0.07853f ; **FLOATING
C198 A.n6 GND 0.70707f ; **FLOATING
C199 A.n7 GND 0.01168f ; **FLOATING
C200 A.n8 GND 0.10424f ; **FLOATING
C201 A.t10 GND 0.10246f ; **FLOATING
C202 A.t4 GND 0.13302f ; **FLOATING
C203 A.n9 GND 0.12625f ; **FLOATING
C204 A.t11 GND 0.09768f ; **FLOATING
C205 A.t12 GND 0.07682f ; **FLOATING
C206 A.n10 GND 0.09948f ; **FLOATING
C207 A.t5 GND 0.13362f ; **FLOATING
C208 A.n11 GND 0.1065f ; **FLOATING
C209 A.n12 GND 0.39567f ; **FLOATING
C210 B.t6 GND 0.09796f ; **FLOATING
C211 B.t0 GND 0.17596f ; **FLOATING
C212 B.n0 GND 0.1384f ; **FLOATING
C213 B.t11 GND 0.10942f ; **FLOATING
C214 B.t12 GND 0.08754f ; **FLOATING
C215 B.n1 GND 0.09211f ; **FLOATING
C216 B.t5 GND 0.17755f ; **FLOATING
C217 B.n2 GND 0.18846f ; **FLOATING
C218 B.t9 GND 0.10135f ; **FLOATING
C219 B.t10 GND 0.0792f ; **FLOATING
C220 B.n3 GND 0.08763f ; **FLOATING
C221 B.t3 GND 0.15138f ; **FLOATING
C222 B.t4 GND 0.12089f ; **FLOATING
C223 B.n4 GND 0.12632f ; **FLOATING
C224 B.n5 GND 0.08114f ; **FLOATING
C225 B.n6 GND 1.44221f ; **FLOATING
C226 B.t7 GND 0.10135f ; **FLOATING
C227 B.t8 GND 0.0792f ; **FLOATING
C228 B.n7 GND 0.08763f ; **FLOATING
C229 B.t1 GND 0.15138f ; **FLOATING
C230 B.t2 GND 0.12089f ; **FLOATING
C231 B.n8 GND 0.12632f ; **FLOATING
C232 B.n9 GND 0.08114f ; **FLOATING
C233 B.n10 GND 0.27788f ; **FLOATING
C234 Y.t17 GND 0.12294f ; **FLOATING
C235 Y.t10 GND 0.02947f ; **FLOATING
C236 Y.t13 GND 0.02947f ; **FLOATING
C237 Y.n0 GND 0.07456f ; **FLOATING
C238 Y.n1 GND 0.51258f ; **FLOATING
C239 Y.t15 GND 0.12294f ; **FLOATING
C240 Y.t14 GND 0.02947f ; **FLOATING
C241 Y.t18 GND 0.02947f ; **FLOATING
C242 Y.n2 GND 0.07456f ; **FLOATING
C243 Y.n3 GND 0.59794f ; **FLOATING
C244 Y.t19 GND 0.02947f ; **FLOATING
C245 Y.t16 GND 0.02947f ; **FLOATING
C246 Y.n4 GND 0.07456f ; **FLOATING
C247 Y.n5 GND 0.31935f ; **FLOATING
C248 Y.t8 GND 0.04f ; **FLOATING
C249 Y.t1 GND 0.04f ; **FLOATING
C250 Y.n6 GND 0.08633f ; **FLOATING
C251 Y.t2 GND 0.04f ; **FLOATING
C252 Y.t6 GND 0.04f ; **FLOATING
C253 Y.n7 GND 0.08605f ; **FLOATING
C254 Y.n8 GND 0.38127f ; **FLOATING
C255 Y.t7 GND 0.04f ; **FLOATING
C256 Y.t3 GND 0.04f ; **FLOATING
C257 Y.n9 GND 0.08605f ; **FLOATING
C258 Y.n10 GND 0.21749f ; **FLOATING
C259 Y.t4 GND 0.04f ; **FLOATING
C260 Y.t5 GND 0.04f ; **FLOATING
C261 Y.n11 GND 0.08605f ; **FLOATING
C262 Y.n12 GND 0.21749f ; **FLOATING
C263 Y.t9 GND 0.04f ; **FLOATING
C264 Y.t0 GND 0.04f ; **FLOATING
C265 Y.n13 GND 0.08605f ; **FLOATING
C266 Y.n14 GND 0.3843f ; **FLOATING
C267 Y.n15 GND 0.3688f ; **FLOATING
C268 Y.t11 GND 0.02947f ; **FLOATING
C269 Y.t12 GND 0.02947f ; **FLOATING
C270 Y.n16 GND 0.07456f ; **FLOATING
C271 Y.n17 GND 0.18186f ; **FLOATING
.ends
