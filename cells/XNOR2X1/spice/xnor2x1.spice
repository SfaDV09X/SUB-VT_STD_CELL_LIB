** sch_path: /foss/designs/xnor2x1.sch
.subckt xnor2x1 A B Y VDD GND
*.PININFO A:I B:I Y:O VDD:B GND:B
XM9 Abar A GND GND sky130_fd_pr__nfet_01v8 L=0.15 W=2.52 nf=3
XM10 Abar A VDD VDD sky130_fd_pr__pfet_01v8 L=0.15 W=0.42 nf=1
XM2 Y A net1 GND sky130_fd_pr__nfet_01v8 L=0.15 W=5.04 nf=6
XM5 net3 A VDD VDD sky130_fd_pr__pfet_01v8 L=0.15 W=0.84 nf=1
XM12 Bbar B VDD VDD sky130_fd_pr__pfet_01v8 L=0.15 W=0.42 nf=1
XM11 Bbar B GND GND sky130_fd_pr__nfet_01v8 L=0.15 W=2.52 nf=3
XM1 net1 Bbar GND GND sky130_fd_pr__nfet_01v8 L=0.15 W=5.04 nf=6
XM3 net2 Abar GND GND sky130_fd_pr__nfet_01v8 L=0.15 W=5.04 nf=6
XM4 Y B net2 GND sky130_fd_pr__nfet_01v8 L=0.15 W=5.04 nf=6
XM6 Y B net3 VDD sky130_fd_pr__pfet_01v8 L=0.15 W=0.84 nf=1
XM8 Y Abar net3 VDD sky130_fd_pr__pfet_01v8 L=0.15 W=0.84 nf=1
XM7 net3 Bbar VDD VDD sky130_fd_pr__pfet_01v8 L=0.15 W=0.84 nf=1
.ends
