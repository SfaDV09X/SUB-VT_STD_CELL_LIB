* NGSPICE file created from nor2x4.ext - technology: sky130A

.subckt nor2x4 A B VDD GND Y
X0 VDD.t7 A.t4 a_194_564.t3 VDD.t6 sky130_fd_pr__pfet_01v8 ad=0.1302 pd=1.15 as=0.1428 ps=1.18 w=0.84 l=0.2
X1 GND.t9 B.t1 Y.t2 GND.t8 sky130_fd_pr__nfet_01v8 ad=0.1176 pd=1.12 as=0.1176 ps=1.12 w=0.84 l=0.26
X2 Y.t8 B.t0 GND.t11 GND.t10 sky130_fd_pr__nfet_01v8 ad=0.1176 pd=1.12 as=0.1176 ps=1.12 w=0.84 l=0.26
X3 GND.t5 A.t0 Y.t9 GND.t4 sky130_fd_pr__nfet_01v8 ad=0.2394 pd=2.25 as=0.1176 ps=1.12 w=0.84 l=0.26
X4 a_194_564.t4 A.t3 VDD.t9 VDD.t8 sky130_fd_pr__pfet_01v8 ad=0.1176 pd=1.12 as=0.1302 ps=1.15 w=0.84 l=0.2
X5 GND.t1 A.t2 Y.t10 GND.t0 sky130_fd_pr__nfet_01v8 ad=0.1176 pd=1.12 as=0.126 ps=1.14 w=0.84 l=0.26
X6 Y.t0 A.t1 GND.t3 GND.t2 sky130_fd_pr__nfet_01v8 ad=0.1176 pd=1.12 as=0.1176 ps=1.12 w=0.84 l=0.26
X7 Y.t7 B.t3 a_194_564.t9 VDD.t14 sky130_fd_pr__pfet_01v8 ad=0.2394 pd=2.25 as=0.1176 ps=1.12 w=0.84 l=0.2
X8 Y.t1 B.t2 GND.t7 GND.t6 sky130_fd_pr__nfet_01v8 ad=0.126 pd=1.14 as=0.2394 ps=2.25 w=0.84 l=0.26
X9 VDD.t1 A.t6 a_194_564.t1 VDD.t0 sky130_fd_pr__pfet_01v8 ad=0.1428 pd=1.18 as=0.1512 ps=1.2 w=0.84 l=0.2
X10 a_194_564.t2 A.t5 VDD.t5 VDD.t4 sky130_fd_pr__pfet_01v8 ad=0.1428 pd=1.18 as=0.1428 ps=1.18 w=0.84 l=0.2
X11 Y.t6 B.t7 a_194_564.t5 VDD.t10 sky130_fd_pr__pfet_01v8 ad=0.1302 pd=1.15 as=0.1176 ps=1.12 w=0.84 l=0.2
X12 a_194_564.t0 A.t7 VDD.t3 VDD.t2 sky130_fd_pr__pfet_01v8 ad=0.1176 pd=1.12 as=0.2394 ps=2.25 w=0.84 l=0.2
X13 a_194_564.t6 B.t6 Y.t5 VDD.t11 sky130_fd_pr__pfet_01v8 ad=0.1512 pd=1.2 as=0.1302 ps=1.15 w=0.84 l=0.2
X14 Y.t4 B.t5 a_194_564.t7 VDD.t12 sky130_fd_pr__pfet_01v8 ad=0.1428 pd=1.18 as=0.1428 ps=1.18 w=0.84 l=0.2
X15 a_194_564.t8 B.t4 Y.t3 VDD.t13 sky130_fd_pr__pfet_01v8 ad=0.1428 pd=1.18 as=0.1428 ps=1.18 w=0.84 l=0.2
C0 A VDD 0.48647f
C1 B A 0.70279f
C2 Y VDD 0.22873f
C3 B Y 0.41519f
C4 Y A 0.26943f
C5 B VDD 0.46713f
R0 Y.n1 Y.t7 340.885
R1 Y.n8 Y.n2 307.341
R2 Y.n1 Y.n0 307.072
R3 Y.n5 Y.n3 127.166
R4 Y.n5 Y.n4 126.647
R5 Y.n7 Y.n6 126.647
R6 Y.n0 Y.t4 39.8695
R7 Y.n0 Y.t3 39.8695
R8 Y.n2 Y.t5 39.8695
R9 Y.n2 Y.t6 32.8338
R10 Y.n6 Y.t1 22.8576
R11 Y.n3 Y.t8 20.0005
R12 Y.n3 Y.t9 20.0005
R13 Y.n4 Y.t0 20.0005
R14 Y.n4 Y.t2 20.0005
R15 Y.n6 Y.t10 20.0005
R16 Y.n8 Y.n7 10.2793
R17 Y Y.n1 0.575019
R18 Y.n7 Y.n5 0.519731
R19 Y Y.n8 0.204827
R20 B B.t3 392.815
R21 B.n1 B.t2 286.301
R22 B.n2 B.t4 246.624
R23 B.n0 B.t7 236.983
R24 B.n3 B.t0 195.643
R25 B.n4 B.n3 185.47
R26 B.n5 B.n1 162.089
R27 B.n5 B.n4 161.3
R28 B.n2 B.t5 137.37
R29 B.n0 B.t6 137.37
R30 B.n3 B.t1 105.669
R31 B.n4 B.n2 98.0602
R32 B.n1 B.n0 93.2237
R33 B B.n5 0.0750192
R34 A.n5 A.t7 489.038
R35 A.n2 A.t5 246.624
R36 A.n0 A.t3 236.983
R37 A.n3 A.t1 195.643
R38 A.n1 A.t0 194.738
R39 A.n1 A.n0 194.46
R40 A.n4 A.n2 194.46
R41 A A.n1 162.264
R42 A.n5 A.n4 161.3
R43 A.n0 A.t4 137.37
R44 A.n2 A.t6 137.37
R45 A.n3 A.t2 105.669
R46 A.n4 A.n3 89.0691
R47 A A.n5 0.0750192
R48 VDD.n3 VDD.t3 456.06
R49 VDD.n4 VDD.n0 406.548
R50 VDD.n3 VDD.n2 343.325
R51 VDD.t0 VDD.t11 240.725
R52 VDD.t4 VDD.t0 232.127
R53 VDD.t12 VDD.t13 232.127
R54 VDD.t13 VDD.t6 232.127
R55 VDD.t11 VDD.t10 219.232
R56 VDD.t6 VDD.t8 219.232
R57 VDD.t10 VDD.t2 206.335
R58 VDD.t8 VDD.t14 206.335
R59 VDD.n1 VDD.t12 120.362
R60 VDD.n1 VDD.t4 111.766
R61 VDD.n0 VDD.t7 39.8695
R62 VDD.n2 VDD.t1 39.8695
R63 VDD.n2 VDD.t5 39.8695
R64 VDD.n0 VDD.t9 32.8338
R65 VDD.n4 VDD.n1 21.7652
R66 VDD.n4 VDD.n3 20.5581
R67 VDD VDD.n4 1.40727
R68 GND.t0 GND.t6 1009.84
R69 GND.t2 GND.t0 973.771
R70 GND.t8 GND.t10 973.771
R71 GND.t10 GND.t4 973.771
R72 GND.n2 GND.t8 504.918
R73 GND.n2 GND.t2 468.853
R74 GND.n4 GND.t7 205.99
R75 GND.n1 GND.t5 205.214
R76 GND.n4 GND.n3 143.325
R77 GND.n1 GND.n0 143.325
R78 GND.n5 GND.n2 68.824
R79 GND.n5 GND.n1 21.3338
R80 GND.n5 GND.n4 20.5581
R81 GND.n3 GND.t1 20.0005
R82 GND.n3 GND.t3 20.0005
R83 GND.n0 GND.t9 20.0005
R84 GND.n0 GND.t11 20.0005
R85 GND GND.n5 1.40727
R86 a_194_564.n7 a_194_564.n6 327.137
R87 a_194_564.n6 a_194_564.n5 326.647
R88 a_194_564.n4 a_194_564.n3 326.647
R89 a_194_564.n2 a_194_564.n1 326.647
R90 a_194_564.n2 a_194_564.n0 316.764
R91 a_194_564.n1 a_194_564.t6 44.56
R92 a_194_564.n5 a_194_564.t8 39.8695
R93 a_194_564.n5 a_194_564.t3 39.8695
R94 a_194_564.n3 a_194_564.t2 39.8695
R95 a_194_564.n3 a_194_564.t7 39.8695
R96 a_194_564.n1 a_194_564.t1 39.8695
R97 a_194_564.t4 a_194_564.n7 32.8338
R98 a_194_564.n7 a_194_564.t9 32.8338
R99 a_194_564.n0 a_194_564.t0 32.8338
R100 a_194_564.n0 a_194_564.t5 32.8338
R101 a_194_564.n4 a_194_564.n2 0.519731
R102 a_194_564.n6 a_194_564.n4 0.519731
C6 Y GND 0.9991f
C7 B GND 0.88465f
C8 A GND 0.96292f
C9 VDD GND 2.54753f
C10 a_194_564.t9 GND 0.03505f ; **FLOATING
C11 a_194_564.t5 GND 0.03505f ; **FLOATING
C12 a_194_564.t0 GND 0.03505f ; **FLOATING
C13 a_194_564.n0 GND 0.07972f ; **FLOATING
C14 a_194_564.t1 GND 0.04256f ; **FLOATING
C15 a_194_564.t6 GND 0.04756f ; **FLOATING
C16 a_194_564.n1 GND 0.09732f ; **FLOATING
C17 a_194_564.n2 GND 0.59231f ; **FLOATING
C18 a_194_564.t7 GND 0.04256f ; **FLOATING
C19 a_194_564.t2 GND 0.04256f ; **FLOATING
C20 a_194_564.n3 GND 0.09231f ; **FLOATING
C21 a_194_564.n4 GND 0.24933f ; **FLOATING
C22 a_194_564.t3 GND 0.04256f ; **FLOATING
C23 a_194_564.t8 GND 0.04256f ; **FLOATING
C24 a_194_564.n5 GND 0.09231f ; **FLOATING
C25 a_194_564.n6 GND 0.43019f ; **FLOATING
C26 a_194_564.n7 GND 0.07757f ; **FLOATING
C27 a_194_564.t4 GND 0.03505f ; **FLOATING
C28 VDD.t9 GND 0.00553f ; **FLOATING
C29 VDD.t7 GND 0.00671f ; **FLOATING
C30 VDD.n0 GND 0.02716f ; **FLOATING
C31 VDD.t14 GND 0.27846f ; **FLOATING
C32 VDD.t8 GND 0.10286f ; **FLOATING
C33 VDD.t6 GND 0.1091f ; **FLOATING
C34 VDD.t13 GND 0.11222f ; **FLOATING
C35 VDD.t12 GND 0.0852f ; **FLOATING
C36 VDD.t2 GND 0.27846f ; **FLOATING
C37 VDD.t10 GND 0.10286f ; **FLOATING
C38 VDD.t11 GND 0.11118f ; **FLOATING
C39 VDD.t0 GND 0.11429f ; **FLOATING
C40 VDD.t4 GND 0.08312f ; **FLOATING
C41 VDD.n1 GND 0.13901f ; **FLOATING
C42 VDD.t5 GND 0.00671f ; **FLOATING
C43 VDD.t1 GND 0.00671f ; **FLOATING
C44 VDD.n2 GND 0.01527f ; **FLOATING
C45 VDD.t3 GND 0.03368f ; **FLOATING
C46 VDD.n3 GND 0.10782f ; **FLOATING
C47 VDD.n4 GND 0.31469f ; **FLOATING
C48 A.t3 GND 0.0763f ; **FLOATING
C49 A.t4 GND 0.06155f ; **FLOATING
C50 A.n0 GND 0.08002f ; **FLOATING
C51 A.t0 GND 0.10032f ; **FLOATING
C52 A.n1 GND 0.08632f ; **FLOATING
C53 A.t7 GND 0.11677f ; **FLOATING
C54 A.t5 GND 0.07746f ; **FLOATING
C55 A.t6 GND 0.06155f ; **FLOATING
C56 A.n2 GND 0.08051f ; **FLOATING
C57 A.t1 GND 0.09943f ; **FLOATING
C58 A.t2 GND 0.08001f ; **FLOATING
C59 A.n3 GND 0.07497f ; **FLOATING
C60 A.n4 GND 0.06144f ; **FLOATING
C61 A.n5 GND 0.26203f ; **FLOATING
C62 B.t3 GND 0.11279f ; **FLOATING
C63 B.t7 GND 0.08398f ; **FLOATING
C64 B.t6 GND 0.06774f ; **FLOATING
C65 B.n0 GND 0.07185f ; **FLOATING
C66 B.t2 GND 0.12856f ; **FLOATING
C67 B.n1 GND 0.09286f ; **FLOATING
C68 B.t4 GND 0.08526f ; **FLOATING
C69 B.t5 GND 0.06774f ; **FLOATING
C70 B.n2 GND 0.07278f ; **FLOATING
C71 B.t0 GND 0.10944f ; **FLOATING
C72 B.t1 GND 0.08806f ; **FLOATING
C73 B.n3 GND 0.09842f ; **FLOATING
C74 B.n4 GND 0.06755f ; **FLOATING
C75 B.n5 GND 0.24028f ; **FLOATING
C76 Y.t7 GND 0.08306f ; **FLOATING
C77 Y.t3 GND 0.02594f ; **FLOATING
C78 Y.t4 GND 0.02594f ; **FLOATING
C79 Y.n0 GND 0.05403f ; **FLOATING
C80 Y.n1 GND 0.37468f ; **FLOATING
C81 Y.t5 GND 0.02594f ; **FLOATING
C82 Y.t6 GND 0.02136f ; **FLOATING
C83 Y.n2 GND 0.04953f ; **FLOATING
C84 Y.t9 GND 0.02136f ; **FLOATING
C85 Y.t8 GND 0.02136f ; **FLOATING
C86 Y.n3 GND 0.05449f ; **FLOATING
C87 Y.t2 GND 0.02136f ; **FLOATING
C88 Y.t0 GND 0.02136f ; **FLOATING
C89 Y.n4 GND 0.05404f ; **FLOATING
C90 Y.n5 GND 0.25373f ; **FLOATING
C91 Y.t10 GND 0.02136f ; **FLOATING
C92 Y.t1 GND 0.02441f ; **FLOATING
C93 Y.n6 GND 0.05709f ; **FLOATING
C94 Y.n7 GND 0.24988f ; **FLOATING
C95 Y.n8 GND 0.28093f ; **FLOATING
.ends
