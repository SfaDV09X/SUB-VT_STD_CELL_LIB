* NGSPICE file created from and2x4.ext - technology: sky130A

.subckt and2x4 A B VDD GND Y
X0 VDD.t35 a_178_564.t19 Y.t7 VDD.t34 sky130_fd_pr__pfet_01v8 ad=0.2394 pd=2.25 as=0.1176 ps=1.12 w=0.84 l=0.21
X1 a_178_564.t4 B.t5 VDD.t9 VDD.t8 sky130_fd_pr__pfet_01v8 ad=0.126 pd=1.14 as=0.1344 ps=1.16 w=0.84 l=0.22
X2 VDD.t25 A.t4 a_178_564.t15 VDD.t24 sky130_fd_pr__pfet_01v8 ad=0.1344 pd=1.16 as=0.1176 ps=1.12 w=0.84 l=0.22
X3 a_286_84.t4 A.t2 a_178_564.t7 GND.t13 sky130_fd_pr__nfet_01v8 ad=0.1176 pd=1.12 as=0.1176 ps=1.12 w=0.84 l=0.26
X4 GND.t3 B.t2 a_286_84.t1 GND.t2 sky130_fd_pr__nfet_01v8 ad=0.1176 pd=1.12 as=0.1176 ps=1.12 w=0.84 l=0.26
X5 a_286_84.t2 B.t1 GND.t7 GND.t6 sky130_fd_pr__nfet_01v8 ad=0.1176 pd=1.12 as=0.1176 ps=1.12 w=0.84 l=0.26
X6 a_178_564.t6 A.t3 a_286_84.t5 GND.t12 sky130_fd_pr__nfet_01v8 ad=0.1176 pd=1.12 as=0.126 ps=1.14 w=0.84 l=0.26
X7 a_178_564.t0 B.t9 VDD.t3 VDD.t2 sky130_fd_pr__pfet_01v8 ad=0.126 pd=1.14 as=0.2394 ps=2.25 w=0.84 l=0.22
X8 Y.t5 a_178_564.t24 VDD.t21 VDD.t20 sky130_fd_pr__pfet_01v8 ad=0.1512 pd=1.2 as=0.1344 ps=1.16 w=0.84 l=0.21
X9 VDD.t15 a_178_564.t21 Y.t2 VDD.t14 sky130_fd_pr__pfet_01v8 ad=0.1176 pd=1.12 as=0.1344 ps=1.16 w=0.84 l=0.21
X10 a_286_84.t0 B.t3 GND.t5 GND.t4 sky130_fd_pr__nfet_01v8 ad=0.126 pd=1.14 as=0.2394 ps=2.25 w=0.84 l=0.26
X11 VDD.t19 a_178_564.t23 Y.t4 VDD.t18 sky130_fd_pr__pfet_01v8 ad=0.1512 pd=1.2 as=0.1512 ps=1.2 w=0.84 l=0.21
X12 a_178_564.t10 A.t9 VDD.t23 VDD.t22 sky130_fd_pr__pfet_01v8 ad=0.1344 pd=1.16 as=0.1428 ps=1.18 w=0.84 l=0.22
X13 a_178_564.t14 A.t5 VDD.t29 VDD.t28 sky130_fd_pr__pfet_01v8 ad=0.1176 pd=1.12 as=0.1176 ps=1.12 w=0.84 l=0.22
X14 GND.t17 a_178_564.t17 Y.t8 GND.t16 sky130_fd_pr__nfet_01v8 ad=0.1176 pd=1.12 as=0.1176 ps=1.12 w=0.84 l=0.29
X15 VDD.t31 A.t8 a_178_564.t11 VDD.t30 sky130_fd_pr__pfet_01v8 ad=0.1344 pd=1.16 as=0.1344 ps=1.16 w=0.84 l=0.22
X16 Y.t3 a_178_564.t22 VDD.t17 VDD.t16 sky130_fd_pr__pfet_01v8 ad=0.1344 pd=1.16 as=0.1512 ps=1.2 w=0.84 l=0.21
X17 a_286_84.t6 A.t0 a_178_564.t9 GND.t15 sky130_fd_pr__nfet_01v8 ad=0.1176 pd=1.12 as=0.1176 ps=1.12 w=0.84 l=0.26
X18 GND.t9 B.t0 a_286_84.t3 GND.t8 sky130_fd_pr__nfet_01v8 ad=0.2394 pd=2.25 as=0.1176 ps=1.12 w=0.84 l=0.26
X19 a_178_564.t8 A.t1 a_286_84.t7 GND.t14 sky130_fd_pr__nfet_01v8 ad=0.1176 pd=1.12 as=0.1176 ps=1.12 w=0.84 l=0.26
X20 VDD.t7 B.t8 a_178_564.t1 VDD.t6 sky130_fd_pr__pfet_01v8 ad=0.1428 pd=1.18 as=0.126 ps=1.14 w=0.84 l=0.22
X21 a_178_564.t2 B.t7 VDD.t1 VDD.t0 sky130_fd_pr__pfet_01v8 ad=0.1344 pd=1.16 as=0.1344 ps=1.16 w=0.84 l=0.22
X22 Y.t1 a_178_564.t20 VDD.t13 VDD.t12 sky130_fd_pr__pfet_01v8 ad=0.1176 pd=1.12 as=0.1176 ps=1.12 w=0.84 l=0.21
X23 Y.t0 a_178_564.t18 GND.t1 GND.t0 sky130_fd_pr__nfet_01v8 ad=0.1176 pd=1.12 as=0.2394 ps=2.25 w=0.84 l=0.29
X24 VDD.t11 B.t6 a_178_564.t3 VDD.t10 sky130_fd_pr__pfet_01v8 ad=0.1344 pd=1.16 as=0.1344 ps=1.16 w=0.84 l=0.22
X25 VDD.t5 B.t4 a_178_564.t5 VDD.t4 sky130_fd_pr__pfet_01v8 ad=0.1176 pd=1.12 as=0.126 ps=1.14 w=0.84 l=0.22
X26 Y.t6 a_178_564.t16 GND.t11 GND.t10 sky130_fd_pr__nfet_01v8 ad=0.2394 pd=2.25 as=0.1176 ps=1.12 w=0.84 l=0.29
X27 a_178_564.t12 A.t7 VDD.t27 VDD.t26 sky130_fd_pr__pfet_01v8 ad=0.1344 pd=1.16 as=0.1344 ps=1.16 w=0.84 l=0.22
X28 VDD.t33 A.t6 a_178_564.t13 VDD.t32 sky130_fd_pr__pfet_01v8 ad=0.1344 pd=1.16 as=0.1344 ps=1.16 w=0.84 l=0.22
C0 Y B 0.00571f
C1 Y VDD 0.66157f
C2 B VDD 0.57657f
C3 A Y 0.01257f
C4 A B 0.78888f
C5 A VDD 0.64037f
R0 Y.n2 Y.n0 307.543
R1 Y.n2 Y.n1 307.072
R2 Y.n6 Y.n5 307.072
R3 Y.n4 Y.t6 147.196
R4 Y.n4 Y.n3 126.647
R5 Y.n1 Y.t3 42.2148
R6 Y.n5 Y.t5 42.2148
R7 Y.n5 Y.t4 42.2148
R8 Y.n0 Y.t1 32.8338
R9 Y.n0 Y.t7 32.8338
R10 Y.n1 Y.t2 32.8338
R11 Y.n3 Y.t0 20.0005
R12 Y.n3 Y.t8 20.0005
R13 Y.n6 Y.n4 10.2793
R14 Y Y.n2 0.329827
R15 Y Y.n6 0.21925
R16 A.n4 A.n0 252.794
R17 A.n1 A.t6 227.708
R18 A.n5 A.t8 227.708
R19 A.n0 A.t4 214.856
R20 A.n2 A.t0 195.643
R21 A.n6 A.t2 195.643
R22 A.n3 A.n2 171.212
R23 A.n7 A.n6 171.212
R24 A A.n7 162.284
R25 A.n4 A.n3 161.3
R26 A.n0 A.t5 124.882
R27 A.n1 A.t7 124.882
R28 A.n5 A.t9 124.882
R29 A.n2 A.t1 105.669
R30 A.n6 A.t3 105.669
R31 A.n3 A.n1 90.4851
R32 A.n7 A.n5 90.4851
R33 A A.n4 0.0557885
R34 B.n4 B.t6 227.708
R35 B.n0 B.t4 221.282
R36 B.n2 B.t9 221.282
R37 B.n5 B.t1 195.643
R38 B.n1 B.t0 189.244
R39 B.n3 B.t3 185.3
R40 B.n1 B.n0 178.121
R41 B.n6 B.n4 178.121
R42 B.n3 B.n2 174.178
R43 B B.n1 162.264
R44 B.n7 B.n3 162.089
R45 B.n7 B.n6 161.3
R46 B.n0 B.t5 124.882
R47 B.n4 B.t7 124.882
R48 B.n2 B.t8 124.882
R49 B.n5 B.t2 105.669
R50 B.n6 B.n5 83.5753
R51 B B.n7 0.0750192
R52 VDD.n13 VDD.t3 417.272
R53 VDD.n4 VDD.t35 414.17
R54 VDD.n4 VDD.n3 343.325
R55 VDD.n5 VDD.n2 343.325
R56 VDD.n6 VDD.n1 343.325
R57 VDD.n7 VDD.n0 343.325
R58 VDD.n16 VDD.n9 343.325
R59 VDD.n15 VDD.n10 343.325
R60 VDD.n14 VDD.n11 343.325
R61 VDD.n13 VDD.n12 343.325
R62 VDD.t20 VDD.t18 245.024
R63 VDD.t18 VDD.t16 245.024
R64 VDD.t22 VDD.t6 240.725
R65 VDD.t30 VDD.t22 232.127
R66 VDD.t0 VDD.t30 232.127
R67 VDD.t10 VDD.t0 232.127
R68 VDD.t26 VDD.t10 232.127
R69 VDD.t32 VDD.t26 232.127
R70 VDD.t8 VDD.t32 232.127
R71 VDD.t24 VDD.t20 229.977
R72 VDD.t16 VDD.t14 227.828
R73 VDD.t6 VDD.t2 223.53
R74 VDD.t4 VDD.t28 214.933
R75 VDD.t28 VDD.t24 214.933
R76 VDD.t14 VDD.t12 210.633
R77 VDD.t12 VDD.t34 210.633
R78 VDD.n8 VDD.t4 141.856
R79 VDD.n8 VDD.t8 81.6747
R80 VDD.n6 VDD.n5 44.2187
R81 VDD.n2 VDD.t19 42.2148
R82 VDD.n2 VDD.t17 42.2148
R83 VDD.n1 VDD.t21 42.2148
R84 VDD.n12 VDD.t7 42.2148
R85 VDD.n14 VDD.n13 41.8914
R86 VDD.n15 VDD.n14 41.8914
R87 VDD.n16 VDD.n15 41.8914
R88 VDD.n5 VDD.n4 41.1157
R89 VDD.n7 VDD.n6 38.7884
R90 VDD.n9 VDD.t33 37.5243
R91 VDD.n9 VDD.t9 37.5243
R92 VDD.n10 VDD.t11 37.5243
R93 VDD.n10 VDD.t27 37.5243
R94 VDD.n11 VDD.t31 37.5243
R95 VDD.n11 VDD.t1 37.5243
R96 VDD.n12 VDD.t23 37.5243
R97 VDD.n3 VDD.t15 32.8338
R98 VDD.n3 VDD.t13 32.8338
R99 VDD.n1 VDD.t25 32.8338
R100 VDD.n0 VDD.t5 32.8338
R101 VDD.n0 VDD.t29 32.8338
R102 VDD.n17 VDD.n7 22.4975
R103 VDD.n17 VDD.n16 17.8429
R104 VDD.n17 VDD.n8 12.7591
R105 VDD VDD.n17 1.69723
R106 GND.n3 GND.t0 3363.11
R107 GND.t0 GND.t16 1027.87
R108 GND.t16 GND.t10 1027.87
R109 GND.t12 GND.t4 1009.84
R110 GND.t13 GND.t12 973.771
R111 GND.t2 GND.t13 973.771
R112 GND.t6 GND.t2 973.771
R113 GND.t14 GND.t6 973.771
R114 GND.t15 GND.t14 973.771
R115 GND.t8 GND.t15 973.771
R116 GND.n3 GND.t8 342.623
R117 GND.n5 GND.t5 247.881
R118 GND.n1 GND.n0 187.542
R119 GND.n2 GND.t9 163.325
R120 GND.n1 GND.t1 163.325
R121 GND.n5 GND.n4 143.325
R122 GND.n6 GND.n5 80.6793
R123 GND.n2 GND.n1 58.1823
R124 GND.n6 GND.n3 40.3453
R125 GND.n4 GND.t3 20.0005
R126 GND.n4 GND.t7 20.0005
R127 GND.n0 GND.t17 20.0005
R128 GND.n0 GND.t11 20.0005
R129 GND.n6 GND.n2 3.10353
R130 GND GND.n6 1.69723
R131 a_286_84.n5 a_286_84.n4 127.166
R132 a_286_84.n2 a_286_84.n0 127.166
R133 a_286_84.n4 a_286_84.n3 126.647
R134 a_286_84.n2 a_286_84.n1 126.647
R135 a_286_84.n0 a_286_84.t0 22.8576
R136 a_286_84.n5 a_286_84.t6 20.0005
R137 a_286_84.t3 a_286_84.n5 20.0005
R138 a_286_84.n3 a_286_84.t2 20.0005
R139 a_286_84.n3 a_286_84.t7 20.0005
R140 a_286_84.n1 a_286_84.t4 20.0005
R141 a_286_84.n1 a_286_84.t1 20.0005
R142 a_286_84.n0 a_286_84.t5 20.0005
R143 a_286_84.n4 a_286_84.n2 0.519731
R144 a_178_564.n15 a_178_564.n13 307.599
R145 a_178_564.n20 a_178_564.n0 307.551
R146 a_178_564.n21 a_178_564.n20 307.072
R147 a_178_564.n19 a_178_564.n18 307.072
R148 a_178_564.n17 a_178_564.n16 307.072
R149 a_178_564.n15 a_178_564.n14 307.072
R150 a_178_564.n1 a_178_564.t19 243.296
R151 a_178_564.n6 a_178_564.t16 215.774
R152 a_178_564.n8 a_178_564.n5 185.915
R153 a_178_564.n10 a_178_564.n8 172.12
R154 a_178_564.n4 a_178_564.n3 160.667
R155 a_178_564.n3 a_178_564.n2 147.814
R156 a_178_564.n5 a_178_564.n4 138.173
R157 a_178_564.n2 a_178_564.n1 134.96
R158 a_178_564.n5 a_178_564.t24 130.829
R159 a_178_564.n7 a_178_564.n6 121.037
R160 a_178_564.n10 a_178_564.n9 107.072
R161 a_178_564.n12 a_178_564.n11 107.072
R162 a_178_564.n4 a_178_564.t23 96.4005
R163 a_178_564.n3 a_178_564.t22 96.4005
R164 a_178_564.n2 a_178_564.t21 96.4005
R165 a_178_564.n1 a_178_564.t20 96.4005
R166 a_178_564.n7 a_178_564.t18 94.7384
R167 a_178_564.n8 a_178_564.n7 84.766
R168 a_178_564.n6 a_178_564.t17 69.8074
R169 a_178_564.n21 a_178_564.t4 37.5243
R170 a_178_564.n18 a_178_564.t12 37.5243
R171 a_178_564.n18 a_178_564.t13 37.5243
R172 a_178_564.n16 a_178_564.t2 37.5243
R173 a_178_564.n16 a_178_564.t3 37.5243
R174 a_178_564.n14 a_178_564.t10 37.5243
R175 a_178_564.n14 a_178_564.t11 37.5243
R176 a_178_564.n13 a_178_564.t1 37.5243
R177 a_178_564.t5 a_178_564.n21 32.8338
R178 a_178_564.n0 a_178_564.t14 32.8338
R179 a_178_564.n0 a_178_564.t15 32.8338
R180 a_178_564.n13 a_178_564.t0 32.8338
R181 a_178_564.n9 a_178_564.t8 20.0005
R182 a_178_564.n9 a_178_564.t9 20.0005
R183 a_178_564.n11 a_178_564.t6 20.0005
R184 a_178_564.n11 a_178_564.t7 20.0005
R185 a_178_564.n15 a_178_564.n12 10.087
R186 a_178_564.n12 a_178_564.n10 1.03896
R187 a_178_564.n17 a_178_564.n15 0.519731
R188 a_178_564.n19 a_178_564.n17 0.519731
R189 a_178_564.n20 a_178_564.n19 0.519731
C6 Y GND 0.63687f
C7 A GND 0.84436f
C8 B GND 1.00501f
C9 VDD GND 3.89682f
C10 a_178_564.t4 GND 0.02549f ; **FLOATING
C11 a_178_564.t15 GND 0.02231f ; **FLOATING
C12 a_178_564.t14 GND 0.02231f ; **FLOATING
C13 a_178_564.n0 GND 0.04705f ; **FLOATING
C14 a_178_564.t23 GND 0.06055f ; **FLOATING
C15 a_178_564.t22 GND 0.06055f ; **FLOATING
C16 a_178_564.t21 GND 0.06055f ; **FLOATING
C17 a_178_564.t20 GND 0.06055f ; **FLOATING
C18 a_178_564.t19 GND 0.08461f ; **FLOATING
C19 a_178_564.n1 GND 0.06913f ; **FLOATING
C20 a_178_564.n2 GND 0.05171f ; **FLOATING
C21 a_178_564.n3 GND 0.05399f ; **FLOATING
C22 a_178_564.n4 GND 0.05273f ; **FLOATING
C23 a_178_564.t24 GND 0.06652f ; **FLOATING
C24 a_178_564.n5 GND 0.06797f ; **FLOATING
C25 a_178_564.t17 GND 0.08361f ; **FLOATING
C26 a_178_564.t16 GND 0.12059f ; **FLOATING
C27 a_178_564.n6 GND 0.07899f ; **FLOATING
C28 a_178_564.t18 GND 0.09187f ; **FLOATING
C29 a_178_564.n7 GND 0.06208f ; **FLOATING
C30 a_178_564.n8 GND 0.07469f ; **FLOATING
C31 a_178_564.t9 GND 0.02231f ; **FLOATING
C32 a_178_564.t8 GND 0.02231f ; **FLOATING
C33 a_178_564.n9 GND 0.05105f ; **FLOATING
C34 a_178_564.n10 GND 0.6189f ; **FLOATING
C35 a_178_564.t7 GND 0.02231f ; **FLOATING
C36 a_178_564.t6 GND 0.02231f ; **FLOATING
C37 a_178_564.n11 GND 0.05105f ; **FLOATING
C38 a_178_564.n12 GND 0.29987f ; **FLOATING
C39 a_178_564.t1 GND 0.02549f ; **FLOATING
C40 a_178_564.t0 GND 0.02231f ; **FLOATING
C41 a_178_564.n13 GND 0.05026f ; **FLOATING
C42 a_178_564.t11 GND 0.02549f ; **FLOATING
C43 a_178_564.t10 GND 0.02549f ; **FLOATING
C44 a_178_564.n14 GND 0.05323f ; **FLOATING
C45 a_178_564.n15 GND 0.4136f ; **FLOATING
C46 a_178_564.t3 GND 0.02549f ; **FLOATING
C47 a_178_564.t2 GND 0.02549f ; **FLOATING
C48 a_178_564.n16 GND 0.05323f ; **FLOATING
C49 a_178_564.n17 GND 0.16104f ; **FLOATING
C50 a_178_564.t13 GND 0.02549f ; **FLOATING
C51 a_178_564.t12 GND 0.02549f ; **FLOATING
C52 a_178_564.n18 GND 0.05323f ; **FLOATING
C53 a_178_564.n19 GND 0.16104f ; **FLOATING
C54 a_178_564.n20 GND 0.27652f ; **FLOATING
C55 a_178_564.n21 GND 0.05005f ; **FLOATING
C56 a_178_564.t5 GND 0.02231f ; **FLOATING
C57 a_286_84.t6 GND 0.01981f ; **FLOATING
C58 a_286_84.t5 GND 0.01981f ; **FLOATING
C59 a_286_84.t0 GND 0.02264f ; **FLOATING
C60 a_286_84.n0 GND 0.05337f ; **FLOATING
C61 a_286_84.t1 GND 0.01981f ; **FLOATING
C62 a_286_84.t4 GND 0.01981f ; **FLOATING
C63 a_286_84.n1 GND 0.05013f ; **FLOATING
C64 a_286_84.n2 GND 0.23534f ; **FLOATING
C65 a_286_84.t7 GND 0.01981f ; **FLOATING
C66 a_286_84.t2 GND 0.01981f ; **FLOATING
C67 a_286_84.n3 GND 0.05013f ; **FLOATING
C68 a_286_84.n4 GND 0.23534f ; **FLOATING
C69 a_286_84.n5 GND 0.05054f ; **FLOATING
C70 a_286_84.t3 GND 0.01981f ; **FLOATING
C71 VDD.t29 GND 0.0055f ; **FLOATING
C72 VDD.t5 GND 0.0055f ; **FLOATING
C73 VDD.n0 GND 0.01283f ; **FLOATING
C74 VDD.t21 GND 0.00707f ; **FLOATING
C75 VDD.t25 GND 0.0055f ; **FLOATING
C76 VDD.n1 GND 0.0144f ; **FLOATING
C77 VDD.t17 GND 0.00707f ; **FLOATING
C78 VDD.t19 GND 0.00707f ; **FLOATING
C79 VDD.n2 GND 0.01598f ; **FLOATING
C80 VDD.t13 GND 0.0055f ; **FLOATING
C81 VDD.t15 GND 0.0055f ; **FLOATING
C82 VDD.n3 GND 0.01283f ; **FLOATING
C83 VDD.t35 GND 0.0265f ; **FLOATING
C84 VDD.n4 GND 0.08603f ; **FLOATING
C85 VDD.n5 GND 0.04986f ; **FLOATING
C86 VDD.n6 GND 0.04893f ; **FLOATING
C87 VDD.n7 GND 0.04029f ; **FLOATING
C88 VDD.t34 GND 0.25843f ; **FLOATING
C89 VDD.t12 GND 0.1013f ; **FLOATING
C90 VDD.t14 GND 0.10544f ; **FLOATING
C91 VDD.t16 GND 0.11371f ; **FLOATING
C92 VDD.t18 GND 0.11784f ; **FLOATING
C93 VDD.t20 GND 0.11423f ; **FLOATING
C94 VDD.t24 GND 0.10699f ; **FLOATING
C95 VDD.t28 GND 0.10337f ; **FLOATING
C96 VDD.t4 GND 0.0858f ; **FLOATING
C97 VDD.t2 GND 0.26256f ; **FLOATING
C98 VDD.t6 GND 0.11164f ; **FLOATING
C99 VDD.t22 GND 0.11371f ; **FLOATING
C100 VDD.t30 GND 0.11164f ; **FLOATING
C101 VDD.t0 GND 0.11164f ; **FLOATING
C102 VDD.t10 GND 0.11164f ; **FLOATING
C103 VDD.t26 GND 0.11164f ; **FLOATING
C104 VDD.t32 GND 0.11164f ; **FLOATING
C105 VDD.t8 GND 0.07546f ; **FLOATING
C106 VDD.n8 GND 0.19238f ; **FLOATING
C107 VDD.t9 GND 0.00629f ; **FLOATING
C108 VDD.t33 GND 0.00629f ; **FLOATING
C109 VDD.n9 GND 0.0144f ; **FLOATING
C110 VDD.t27 GND 0.00629f ; **FLOATING
C111 VDD.t11 GND 0.00629f ; **FLOATING
C112 VDD.n10 GND 0.0144f ; **FLOATING
C113 VDD.t1 GND 0.00629f ; **FLOATING
C114 VDD.t31 GND 0.00629f ; **FLOATING
C115 VDD.n11 GND 0.0144f ; **FLOATING
C116 VDD.t23 GND 0.00629f ; **FLOATING
C117 VDD.t7 GND 0.00707f ; **FLOATING
C118 VDD.n12 GND 0.01519f ; **FLOATING
C119 VDD.t3 GND 0.02691f ; **FLOATING
C120 VDD.n13 GND 0.0884f ; **FLOATING
C121 VDD.n14 GND 0.04924f ; **FLOATING
C122 VDD.n15 GND 0.04924f ; **FLOATING
C123 VDD.n16 GND 0.03967f ; **FLOATING
C124 VDD.n17 GND 0.44034f ; **FLOATING
C125 B.t4 GND 0.08601f ; **FLOATING
C126 B.t5 GND 0.0693f ; **FLOATING
C127 B.n0 GND 0.08786f ; **FLOATING
C128 B.t0 GND 0.10239f ; **FLOATING
C129 B.n1 GND 0.09229f ; **FLOATING
C130 B.t9 GND 0.08601f ; **FLOATING
C131 B.t8 GND 0.0693f ; **FLOATING
C132 B.n2 GND 0.08731f ; **FLOATING
C133 B.t3 GND 0.10171f ; **FLOATING
C134 B.n3 GND 0.09332f ; **FLOATING
C135 B.t6 GND 0.08688f ; **FLOATING
C136 B.t7 GND 0.0693f ; **FLOATING
C137 B.n4 GND 0.08813f ; **FLOATING
C138 B.t1 GND 0.10178f ; **FLOATING
C139 B.t2 GND 0.0819f ; **FLOATING
C140 B.n5 GND 0.07768f ; **FLOATING
C141 B.n6 GND 0.06558f ; **FLOATING
C142 B.n7 GND 0.22347f ; **FLOATING
C143 A.t4 GND 0.09328f ; **FLOATING
C144 A.t5 GND 0.07593f ; **FLOATING
C145 A.n0 GND 0.10857f ; **FLOATING
C146 A.t6 GND 0.0952f ; **FLOATING
C147 A.t7 GND 0.07593f ; **FLOATING
C148 A.n1 GND 0.07873f ; **FLOATING
C149 A.t0 GND 0.11153f ; **FLOATING
C150 A.t1 GND 0.08974f ; **FLOATING
C151 A.n2 GND 0.103f ; **FLOATING
C152 A.n3 GND 0.07181f ; **FLOATING
C153 A.n4 GND 0.30877f ; **FLOATING
C154 A.t8 GND 0.0952f ; **FLOATING
C155 A.t9 GND 0.07593f ; **FLOATING
C156 A.n5 GND 0.07873f ; **FLOATING
C157 A.t2 GND 0.11153f ; **FLOATING
C158 A.t3 GND 0.08974f ; **FLOATING
C159 A.n6 GND 0.103f ; **FLOATING
C160 A.n7 GND 0.07271f ; **FLOATING
C161 Y.t7 GND 0.01649f ; **FLOATING
C162 Y.t1 GND 0.01649f ; **FLOATING
C163 Y.n0 GND 0.03476f ; **FLOATING
C164 Y.t2 GND 0.01649f ; **FLOATING
C165 Y.t3 GND 0.0212f ; **FLOATING
C166 Y.n1 GND 0.03934f ; **FLOATING
C167 Y.n2 GND 0.1885f ; **FLOATING
C168 Y.t6 GND 0.06811f ; **FLOATING
C169 Y.t8 GND 0.01649f ; **FLOATING
C170 Y.t0 GND 0.01649f ; **FLOATING
C171 Y.n3 GND 0.04171f ; **FLOATING
C172 Y.n4 GND 0.2892f ; **FLOATING
C173 Y.t4 GND 0.0212f ; **FLOATING
C174 Y.t5 GND 0.0212f ; **FLOATING
C175 Y.n5 GND 0.04405f ; **FLOATING
C176 Y.n6 GND 0.17715f ; **FLOATING
.ends
