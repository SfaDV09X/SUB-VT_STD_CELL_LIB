* NGSPICE file created from oai3x4.ext - technology: sky130A

.subckt oai3x4 VDD GND A B C Y
X0 a_182_564.t3 B.t7 Y.t9 VDD.t3 sky130_fd_pr__pfet_01v8 ad=0.1428 pd=1.18 as=0.1428 ps=1.18 w=0.84 l=0.2
X1 VDD.t9 C.t6 Y.t3 VDD.t8 sky130_fd_pr__pfet_01v8 ad=0.1428 pd=1.18 as=0.1428 ps=1.18 w=0.84 l=0.2
X2 Y.t6 C.t5 VDD.t11 VDD.t10 sky130_fd_pr__pfet_01v8 ad=0.2646 pd=2.31 as=0.1428 ps=1.18 w=0.84 l=0.2
X3 GND.t10 C.t2 a_79_84.t7 GND.t9 sky130_fd_pr__nfet_01v8 ad=0.1176 pd=1.12 as=0.1176 ps=1.12 w=0.84 l=0.26
X4 a_79_84.t8 C.t1 GND.t12 GND.t11 sky130_fd_pr__nfet_01v8 ad=0.1176 pd=1.12 as=0.1176 ps=1.12 w=0.84 l=0.26
X5 GND.t14 C.t0 a_79_84.t9 GND.t13 sky130_fd_pr__nfet_01v8 ad=0.2394 pd=2.25 as=0.1176 ps=1.12 w=0.84 l=0.26
X6 a_79_84.t6 C.t3 GND.t8 GND.t7 sky130_fd_pr__nfet_01v8 ad=0.1176 pd=1.12 as=0.1176 ps=1.12 w=0.84 l=0.26
X7 VDD.t19 A.t7 a_182_564.t9 VDD.t18 sky130_fd_pr__pfet_01v8 ad=0.1428 pd=1.18 as=0.1428 ps=1.18 w=0.84 l=0.2
X8 a_79_84.t0 B.t4 Y.t8 GND.t0 sky130_fd_pr__nfet_01v8 ad=0.1176 pd=1.12 as=0.126 ps=1.14 w=0.84 l=0.26
X9 Y.t14 B.t3 a_79_84.t1 GND.t1 sky130_fd_pr__nfet_01v8 ad=0.1176 pd=1.12 as=0.1176 ps=1.12 w=0.84 l=0.26
X10 a_79_84.t11 A.t3 Y.t10 GND.t16 sky130_fd_pr__nfet_01v8 ad=0.1176 pd=1.12 as=0.1176 ps=1.12 w=0.84 l=0.26
X11 Y.t4 A.t2 a_79_84.t12 GND.t17 sky130_fd_pr__nfet_01v8 ad=0.1176 pd=1.12 as=0.1176 ps=1.12 w=0.84 l=0.26
X12 a_79_84.t2 B.t2 Y.t16 GND.t2 sky130_fd_pr__nfet_01v8 ad=0.1176 pd=1.12 as=0.1176 ps=1.12 w=0.84 l=0.26
X13 Y.t18 B.t10 a_182_564.t0 VDD.t0 sky130_fd_pr__pfet_01v8 ad=0.1428 pd=1.18 as=0.1512 ps=1.2 w=0.84 l=0.2
X14 a_182_564.t10 A.t6 VDD.t23 VDD.t22 sky130_fd_pr__pfet_01v8 ad=0.1428 pd=1.18 as=0.1428 ps=1.18 w=0.84 l=0.2
X15 Y.t1 A.t4 a_79_84.t10 GND.t15 sky130_fd_pr__nfet_01v8 ad=0.126 pd=1.14 as=0.2394 ps=2.25 w=0.84 l=0.26
X16 a_182_564.t1 B.t9 Y.t5 VDD.t1 sky130_fd_pr__pfet_01v8 ad=0.1428 pd=1.18 as=0.1428 ps=1.18 w=0.84 l=0.2
X17 Y.t15 B.t6 a_182_564.t4 VDD.t4 sky130_fd_pr__pfet_01v8 ad=0.1428 pd=1.18 as=0.1428 ps=1.18 w=0.84 l=0.2
X18 VDD.t15 A.t9 a_182_564.t7 VDD.t14 sky130_fd_pr__pfet_01v8 ad=0.1428 pd=1.18 as=0.1428 ps=1.18 w=0.84 l=0.2
X19 Y.t13 A.t0 a_79_84.t14 GND.t19 sky130_fd_pr__nfet_01v8 ad=0.1176 pd=1.12 as=0.1176 ps=1.12 w=0.84 l=0.26
X20 a_79_84.t4 B.t0 Y.t7 GND.t4 sky130_fd_pr__nfet_01v8 ad=0.1176 pd=1.12 as=0.1176 ps=1.12 w=0.84 l=0.26
X21 GND.t6 C.t4 a_79_84.t5 GND.t5 sky130_fd_pr__nfet_01v8 ad=0.1176 pd=1.12 as=0.1176 ps=1.12 w=0.84 l=0.26
X22 a_182_564.t6 A.t10 VDD.t13 VDD.t12 sky130_fd_pr__pfet_01v8 ad=0.1512 pd=1.2 as=0.2646 ps=2.31 w=0.84 l=0.2
X23 a_182_564.t5 B.t5 Y.t17 VDD.t5 sky130_fd_pr__pfet_01v8 ad=0.1428 pd=1.18 as=0.1428 ps=1.18 w=0.84 l=0.2
X24 a_182_564.t8 A.t8 VDD.t17 VDD.t16 sky130_fd_pr__pfet_01v8 ad=0.1428 pd=1.18 as=0.1428 ps=1.18 w=0.84 l=0.2
X25 VDD.t21 A.t5 a_182_564.t11 VDD.t20 sky130_fd_pr__pfet_01v8 ad=0.1428 pd=1.18 as=0.1428 ps=1.18 w=0.84 l=0.2
X26 Y.t0 B.t1 a_79_84.t3 GND.t3 sky130_fd_pr__nfet_01v8 ad=0.1176 pd=1.12 as=0.1176 ps=1.12 w=0.84 l=0.26
X27 a_79_84.t13 A.t1 Y.t2 GND.t18 sky130_fd_pr__nfet_01v8 ad=0.1176 pd=1.12 as=0.1176 ps=1.12 w=0.84 l=0.26
X28 Y.t12 B.t8 a_182_564.t2 VDD.t2 sky130_fd_pr__pfet_01v8 ad=0.1428 pd=1.18 as=0.1428 ps=1.18 w=0.84 l=0.2
X29 Y.t11 C.t7 VDD.t7 VDD.t6 sky130_fd_pr__pfet_01v8 ad=0.1428 pd=1.18 as=0.1428 ps=1.18 w=0.84 l=0.2
C0 B VDD 0.5412f
C1 C A 0.07637f
C2 VDD A 0.60697f
C3 Y B 0.48083f
C4 C VDD 0.30877f
C5 Y A 0.24658f
C6 B A 0.98002f
C7 C Y 0.08667f
C8 C B 0.033f
C9 Y VDD 0.60439f
R0 Y.n1 Y.t6 347.459
R1 Y.n1 Y.n0 307.072
R2 Y.n3 Y.n2 307.072
R3 Y.n5 Y.n4 307.072
R4 Y.n16 Y.n15 307.072
R5 Y.n8 Y.n6 127.166
R6 Y.n14 Y.n13 126.907
R7 Y.n8 Y.n7 126.647
R8 Y.n10 Y.n9 126.647
R9 Y.n12 Y.n11 126.647
R10 Y.n0 Y.t11 39.8695
R11 Y.n0 Y.t3 39.8695
R12 Y.n2 Y.t15 39.8695
R13 Y.n2 Y.t17 39.8695
R14 Y.n4 Y.t12 39.8695
R15 Y.n4 Y.t9 39.8695
R16 Y.n15 Y.t18 39.8695
R17 Y.n15 Y.t5 39.8695
R18 Y.n13 Y.t1 22.8576
R19 Y.n6 Y.t13 20.0005
R20 Y.n6 Y.t7 20.0005
R21 Y.n7 Y.t0 20.0005
R22 Y.n7 Y.t2 20.0005
R23 Y.n9 Y.t4 20.0005
R24 Y.n9 Y.t16 20.0005
R25 Y.n11 Y.t14 20.0005
R26 Y.n11 Y.t10 20.0005
R27 Y.n13 Y.t8 20.0005
R28 Y.n16 Y.n14 10.2793
R29 Y.n5 Y.n3 1.03896
R30 Y.n3 Y.n1 0.779346
R31 Y Y.n16 0.59425
R32 Y.n12 Y.n10 0.519731
R33 Y.n10 Y.n8 0.519731
R34 Y Y.n5 0.445212
R35 Y.n14 Y.n12 0.260115
R36 C.n0 C.t7 246.624
R37 C.n0 C.t5 246.624
R38 C.n3 C.t0 223.492
R39 C.n1 C.t4 223.492
R40 C.n4 C.n3 166.728
R41 C C.n4 161.356
R42 C.n3 C.n2 145.672
R43 C.n2 C.n1 145.672
R44 C.n0 C.t6 137.37
R45 C.n4 C.n0 93.2237
R46 C.n2 C.t2 77.862
R47 C.n1 C.t3 77.862
R48 C.n3 C.t1 77.862
R49 B.n1 B.t0 291.139
R50 B.n0 B.t5 246.624
R51 B.n2 B.t7 246.624
R52 B.n6 B.t9 246.624
R53 B.n3 B.t1 195.643
R54 B.n7 B.t3 195.643
R55 B.n4 B.n3 185.47
R56 B.n8 B.n7 185.47
R57 B.n5 B.n1 162.339
R58 B B.n8 162.284
R59 B.n5 B.n4 161.3
R60 B.n0 B.t6 137.37
R61 B.n2 B.t8 137.37
R62 B.n6 B.t10 137.37
R63 B.n3 B.t2 105.669
R64 B.n7 B.t4 105.669
R65 B.n1 B.n0 98.0602
R66 B.n4 B.n2 98.0602
R67 B.n8 B.n6 98.0602
R68 B B.n5 0.0557885
R69 A.n3 A.t5 489.332
R70 A.n4 A.t10 326.993
R71 A.n0 A.t6 246.624
R72 A.n5 A.t8 246.624
R73 A.n1 A.t0 195.643
R74 A.n6 A.t2 195.643
R75 A.n2 A.n0 194.46
R76 A.n7 A.n5 194.46
R77 A.n4 A.t4 189.901
R78 A.n8 A.n4 162.089
R79 A.n3 A.n2 161.3
R80 A.n8 A.n7 161.3
R81 A.n0 A.t7 137.37
R82 A.n5 A.t9 137.37
R83 A.n1 A.t1 105.669
R84 A.n6 A.t3 105.669
R85 A.n2 A.n1 89.0691
R86 A.n7 A.n6 89.0691
R87 A A.n8 0.59425
R88 A A.n3 0.445212
R89 VDD.n7 VDD.t13 467.75
R90 VDD.n3 VDD.n2 385.214
R91 VDD.n3 VDD.n1 343.325
R92 VDD.n4 VDD.n0 343.325
R93 VDD.n7 VDD.n6 343.325
R94 VDD.t0 VDD.t12 240.725
R95 VDD.t1 VDD.t0 232.127
R96 VDD.t14 VDD.t1 232.127
R97 VDD.t16 VDD.t14 232.127
R98 VDD.t2 VDD.t16 232.127
R99 VDD.t3 VDD.t2 232.127
R100 VDD.t18 VDD.t22 232.127
R101 VDD.t22 VDD.t4 232.127
R102 VDD.t4 VDD.t5 232.127
R103 VDD.t5 VDD.t20 232.127
R104 VDD.t20 VDD.t6 232.127
R105 VDD.t6 VDD.t8 232.127
R106 VDD.t8 VDD.t10 232.127
R107 VDD.n5 VDD.t3 227.828
R108 VDD.n4 VDD.n3 83.7823
R109 VDD.n8 VDD.n7 72.9217
R110 VDD.n2 VDD.t9 39.8695
R111 VDD.n2 VDD.t11 39.8695
R112 VDD.n1 VDD.t21 39.8695
R113 VDD.n1 VDD.t7 39.8695
R114 VDD.n0 VDD.t19 39.8695
R115 VDD.n0 VDD.t23 39.8695
R116 VDD.n6 VDD.t15 39.8695
R117 VDD.n6 VDD.t17 39.8695
R118 VDD.n8 VDD.n5 14.8005
R119 VDD.n8 VDD.n4 10.8611
R120 VDD.n5 VDD.t18 4.29914
R121 VDD VDD.n8 1.5729
R122 GND.t0 GND.t15 1009.84
R123 GND.t1 GND.t0 973.771
R124 GND.t16 GND.t1 973.771
R125 GND.t17 GND.t16 973.771
R126 GND.t2 GND.t17 973.771
R127 GND.t3 GND.t2 973.771
R128 GND.t18 GND.t19 973.771
R129 GND.t19 GND.t4 973.771
R130 GND.t4 GND.t5 973.771
R131 GND.t5 GND.t7 973.771
R132 GND.t7 GND.t9 973.771
R133 GND.t9 GND.t11 973.771
R134 GND.t11 GND.t13 973.771
R135 GND.n4 GND.t3 955.739
R136 GND.n2 GND.t14 205.214
R137 GND.n3 GND.n0 143.325
R138 GND.n2 GND.n1 143.325
R139 GND.n5 GND.n3 73.6975
R140 GND.n5 GND.n4 46.8005
R141 GND.n3 GND.n2 41.8914
R142 GND.n0 GND.t6 20.0005
R143 GND.n0 GND.t8 20.0005
R144 GND.n1 GND.t10 20.0005
R145 GND.n1 GND.t12 20.0005
R146 GND.n4 GND.t18 18.0333
R147 GND GND.n5 1.5729
R148 a_79_84.n4 a_79_84.t10 156.369
R149 a_79_84.n2 a_79_84.n0 107.591
R150 a_79_84.n12 a_79_84.n11 107.072
R151 a_79_84.n2 a_79_84.n1 107.072
R152 a_79_84.n10 a_79_84.n9 107.072
R153 a_79_84.n8 a_79_84.n7 107.072
R154 a_79_84.n6 a_79_84.n5 107.072
R155 a_79_84.n4 a_79_84.n3 107.072
R156 a_79_84.t4 a_79_84.n12 20.0005
R157 a_79_84.n12 a_79_84.t5 20.0005
R158 a_79_84.n0 a_79_84.t8 20.0005
R159 a_79_84.n0 a_79_84.t9 20.0005
R160 a_79_84.n1 a_79_84.t6 20.0005
R161 a_79_84.n1 a_79_84.t7 20.0005
R162 a_79_84.n9 a_79_84.t13 20.0005
R163 a_79_84.n9 a_79_84.t14 20.0005
R164 a_79_84.n7 a_79_84.t2 20.0005
R165 a_79_84.n7 a_79_84.t3 20.0005
R166 a_79_84.n5 a_79_84.t11 20.0005
R167 a_79_84.n5 a_79_84.t12 20.0005
R168 a_79_84.n3 a_79_84.t0 20.0005
R169 a_79_84.n3 a_79_84.t1 20.0005
R170 a_79_84.n6 a_79_84.n4 0.519731
R171 a_79_84.n8 a_79_84.n6 0.519731
R172 a_79_84.n10 a_79_84.n8 0.519731
R173 a_79_84.n11 a_79_84.n10 0.519731
R174 a_79_84.n11 a_79_84.n2 0.519731
R175 a_182_564.n9 a_182_564.n8 327.166
R176 a_182_564.n8 a_182_564.n7 326.647
R177 a_182_564.n6 a_182_564.n5 326.647
R178 a_182_564.n4 a_182_564.n3 326.647
R179 a_182_564.n2 a_182_564.n1 326.647
R180 a_182_564.n2 a_182_564.n0 316.783
R181 a_182_564.n0 a_182_564.t6 44.56
R182 a_182_564.t5 a_182_564.n9 39.8695
R183 a_182_564.n9 a_182_564.t11 39.8695
R184 a_182_564.n0 a_182_564.t0 39.8695
R185 a_182_564.n7 a_182_564.t10 39.8695
R186 a_182_564.n7 a_182_564.t4 39.8695
R187 a_182_564.n5 a_182_564.t3 39.8695
R188 a_182_564.n5 a_182_564.t9 39.8695
R189 a_182_564.n3 a_182_564.t8 39.8695
R190 a_182_564.n3 a_182_564.t2 39.8695
R191 a_182_564.n1 a_182_564.t1 39.8695
R192 a_182_564.n1 a_182_564.t7 39.8695
R193 a_182_564.n4 a_182_564.n2 0.519731
R194 a_182_564.n6 a_182_564.n4 0.519731
R195 a_182_564.n8 a_182_564.n6 0.519731
C10 Y GND 0.9582f
C11 C GND 0.67802f
C12 B GND 0.92427f
C13 A GND 0.94658f
C14 VDD GND 3.44511f
C15 a_182_564.t11 GND 0.0419f ; **FLOATING
C16 a_182_564.t0 GND 0.0419f ; **FLOATING
C17 a_182_564.t6 GND 0.04683f ; **FLOATING
C18 a_182_564.n0 GND 0.09824f ; **FLOATING
C19 a_182_564.t7 GND 0.0419f ; **FLOATING
C20 a_182_564.t1 GND 0.0419f ; **FLOATING
C21 a_182_564.n1 GND 0.0909f ; **FLOATING
C22 a_182_564.n2 GND 0.58932f ; **FLOATING
C23 a_182_564.t2 GND 0.0419f ; **FLOATING
C24 a_182_564.t8 GND 0.0419f ; **FLOATING
C25 a_182_564.n3 GND 0.0909f ; **FLOATING
C26 a_182_564.n4 GND 0.24551f ; **FLOATING
C27 a_182_564.t9 GND 0.0419f ; **FLOATING
C28 a_182_564.t3 GND 0.0419f ; **FLOATING
C29 a_182_564.n5 GND 0.0909f ; **FLOATING
C30 a_182_564.n6 GND 0.24551f ; **FLOATING
C31 a_182_564.t4 GND 0.0419f ; **FLOATING
C32 a_182_564.t10 GND 0.0419f ; **FLOATING
C33 a_182_564.n7 GND 0.0909f ; **FLOATING
C34 a_182_564.n8 GND 0.43273f ; **FLOATING
C35 a_182_564.n9 GND 0.0912f ; **FLOATING
C36 a_182_564.t5 GND 0.0419f ; **FLOATING
C37 a_79_84.t5 GND 0.02224f ; **FLOATING
C38 a_79_84.t9 GND 0.02224f ; **FLOATING
C39 a_79_84.t8 GND 0.02224f ; **FLOATING
C40 a_79_84.n0 GND 0.05146f ; **FLOATING
C41 a_79_84.t7 GND 0.02224f ; **FLOATING
C42 a_79_84.t6 GND 0.02224f ; **FLOATING
C43 a_79_84.n1 GND 0.05089f ; **FLOATING
C44 a_79_84.n2 GND 0.27475f ; **FLOATING
C45 a_79_84.t10 GND 0.09937f ; **FLOATING
C46 a_79_84.t1 GND 0.02224f ; **FLOATING
C47 a_79_84.t0 GND 0.02224f ; **FLOATING
C48 a_79_84.n3 GND 0.05089f ; **FLOATING
C49 a_79_84.n4 GND 0.37712f ; **FLOATING
C50 a_79_84.t12 GND 0.02224f ; **FLOATING
C51 a_79_84.t11 GND 0.02224f ; **FLOATING
C52 a_79_84.n5 GND 0.05089f ; **FLOATING
C53 a_79_84.n6 GND 0.15634f ; **FLOATING
C54 a_79_84.t3 GND 0.02224f ; **FLOATING
C55 a_79_84.t2 GND 0.02224f ; **FLOATING
C56 a_79_84.n7 GND 0.05089f ; **FLOATING
C57 a_79_84.n8 GND 0.15634f ; **FLOATING
C58 a_79_84.t14 GND 0.02224f ; **FLOATING
C59 a_79_84.t13 GND 0.02224f ; **FLOATING
C60 a_79_84.n9 GND 0.05089f ; **FLOATING
C61 a_79_84.n10 GND 0.15634f ; **FLOATING
C62 a_79_84.n11 GND 0.15634f ; **FLOATING
C63 a_79_84.n12 GND 0.05089f ; **FLOATING
C64 a_79_84.t4 GND 0.02224f ; **FLOATING
C65 VDD.t23 GND 0.0071f ; **FLOATING
C66 VDD.t19 GND 0.0071f ; **FLOATING
C67 VDD.n0 GND 0.01615f ; **FLOATING
C68 VDD.t7 GND 0.0071f ; **FLOATING
C69 VDD.t21 GND 0.0071f ; **FLOATING
C70 VDD.n1 GND 0.01615f ; **FLOATING
C71 VDD.t11 GND 0.0071f ; **FLOATING
C72 VDD.t9 GND 0.0071f ; **FLOATING
C73 VDD.n2 GND 0.02302f ; **FLOATING
C74 VDD.n3 GND 0.1264f ; **FLOATING
C75 VDD.n4 GND 0.05695f ; **FLOATING
C76 VDD.t10 GND 0.28797f ; **FLOATING
C77 VDD.t8 GND 0.1187f ; **FLOATING
C78 VDD.t6 GND 0.1187f ; **FLOATING
C79 VDD.t20 GND 0.1187f ; **FLOATING
C80 VDD.t5 GND 0.1187f ; **FLOATING
C81 VDD.t4 GND 0.1187f ; **FLOATING
C82 VDD.t22 GND 0.1187f ; **FLOATING
C83 VDD.t18 GND 0.06045f ; **FLOATING
C84 VDD.t12 GND 0.29016f ; **FLOATING
C85 VDD.t0 GND 0.1209f ; **FLOATING
C86 VDD.t1 GND 0.1187f ; **FLOATING
C87 VDD.t14 GND 0.1187f ; **FLOATING
C88 VDD.t16 GND 0.1187f ; **FLOATING
C89 VDD.t2 GND 0.1187f ; **FLOATING
C90 VDD.t3 GND 0.1176f ; **FLOATING
C91 VDD.n5 GND 0.18685f ; **FLOATING
C92 VDD.t17 GND 0.0071f ; **FLOATING
C93 VDD.t15 GND 0.0071f ; **FLOATING
C94 VDD.n6 GND 0.01615f ; **FLOATING
C95 VDD.t13 GND 0.03794f ; **FLOATING
C96 VDD.n7 GND 0.13738f ; **FLOATING
C97 VDD.n8 GND 0.4103f ; **FLOATING
C98 A.t5 GND 0.12931f ; **FLOATING
C99 A.t6 GND 0.08567f ; **FLOATING
C100 A.t7 GND 0.06807f ; **FLOATING
C101 A.n0 GND 0.08904f ; **FLOATING
C102 A.t0 GND 0.10996f ; **FLOATING
C103 A.t1 GND 0.08848f ; **FLOATING
C104 A.n1 GND 0.08291f ; **FLOATING
C105 A.n2 GND 0.06795f ; **FLOATING
C106 A.n3 GND 0.39504f ; **FLOATING
C107 A.t10 GND 0.10048f ; **FLOATING
C108 A.t4 GND 0.11012f ; **FLOATING
C109 A.n4 GND 0.12016f ; **FLOATING
C110 A.t8 GND 0.08567f ; **FLOATING
C111 A.t9 GND 0.06807f ; **FLOATING
C112 A.n5 GND 0.08904f ; **FLOATING
C113 A.t2 GND 0.10996f ; **FLOATING
C114 A.t3 GND 0.08848f ; **FLOATING
C115 A.n6 GND 0.08291f ; **FLOATING
C116 A.n7 GND 0.06795f ; **FLOATING
C117 A.n8 GND 0.29867f ; **FLOATING
C118 B.t5 GND 0.089f ; **FLOATING
C119 B.t6 GND 0.07071f ; **FLOATING
C120 B.n0 GND 0.07597f ; **FLOATING
C121 B.t0 GND 0.13501f ; **FLOATING
C122 B.n1 GND 0.09607f ; **FLOATING
C123 B.t7 GND 0.089f ; **FLOATING
C124 B.t8 GND 0.07071f ; **FLOATING
C125 B.n2 GND 0.07597f ; **FLOATING
C126 B.t1 GND 0.11424f ; **FLOATING
C127 B.t2 GND 0.09192f ; **FLOATING
C128 B.n3 GND 0.10273f ; **FLOATING
C129 B.n4 GND 0.07051f ; **FLOATING
C130 B.n5 GND 0.30548f ; **FLOATING
C131 B.t9 GND 0.089f ; **FLOATING
C132 B.t10 GND 0.07071f ; **FLOATING
C133 B.n6 GND 0.07597f ; **FLOATING
C134 B.t3 GND 0.11424f ; **FLOATING
C135 B.t4 GND 0.09192f ; **FLOATING
C136 B.n7 GND 0.10273f ; **FLOATING
C137 B.n8 GND 0.07143f ; **FLOATING
C138 C.t7 GND 0.04575f ; **FLOATING
C139 C.t5 GND 0.04575f ; **FLOATING
C140 C.t6 GND 0.03635f ; **FLOATING
C141 C.n0 GND 0.05621f ; **FLOATING
C142 C.t1 GND 0.04301f ; **FLOATING
C143 C.t0 GND 0.06137f ; **FLOATING
C144 C.t2 GND 0.04301f ; **FLOATING
C145 C.t3 GND 0.04301f ; **FLOATING
C146 C.t4 GND 0.06137f ; **FLOATING
C147 C.n1 GND 0.04458f ; **FLOATING
C148 C.n2 GND 0.03376f ; **FLOATING
C149 C.n3 GND 0.06f ; **FLOATING
C150 C.n4 GND 0.03545f ; **FLOATING
C151 Y.t6 GND 0.1194f ; **FLOATING
C152 Y.t3 GND 0.03435f ; **FLOATING
C153 Y.t11 GND 0.03435f ; **FLOATING
C154 Y.n0 GND 0.07156f ; **FLOATING
C155 Y.n1 GND 0.40548f ; **FLOATING
C156 Y.t17 GND 0.03435f ; **FLOATING
C157 Y.t15 GND 0.03435f ; **FLOATING
C158 Y.n2 GND 0.07156f ; **FLOATING
C159 Y.n3 GND 0.30557f ; **FLOATING
C160 Y.t9 GND 0.03435f ; **FLOATING
C161 Y.t12 GND 0.03435f ; **FLOATING
C162 Y.n4 GND 0.07156f ; **FLOATING
C163 Y.n5 GND 0.2621f ; **FLOATING
C164 Y.t7 GND 0.02829f ; **FLOATING
C165 Y.t13 GND 0.02829f ; **FLOATING
C166 Y.n6 GND 0.07217f ; **FLOATING
C167 Y.t2 GND 0.02829f ; **FLOATING
C168 Y.t0 GND 0.02829f ; **FLOATING
C169 Y.n7 GND 0.07158f ; **FLOATING
C170 Y.n8 GND 0.33606f ; **FLOATING
C171 Y.t16 GND 0.02829f ; **FLOATING
C172 Y.t4 GND 0.02829f ; **FLOATING
C173 Y.n9 GND 0.07158f ; **FLOATING
C174 Y.n10 GND 0.19209f ; **FLOATING
C175 Y.t10 GND 0.02829f ; **FLOATING
C176 Y.t14 GND 0.02829f ; **FLOATING
C177 Y.n11 GND 0.07158f ; **FLOATING
C178 Y.n12 GND 0.15832f ; **FLOATING
C179 Y.t8 GND 0.02829f ; **FLOATING
C180 Y.t1 GND 0.03233f ; **FLOATING
C181 Y.n13 GND 0.07585f ; **FLOATING
C182 Y.n14 GND 0.3645f ; **FLOATING
C183 Y.t5 GND 0.03435f ; **FLOATING
C184 Y.t18 GND 0.03435f ; **FLOATING
C185 Y.n15 GND 0.07156f ; **FLOATING
C186 Y.n16 GND 0.3528f ; **FLOATING
.ends
