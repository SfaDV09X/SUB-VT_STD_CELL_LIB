** sch_path: /foss/designs/moai4x1.sch
.subckt moai4x1 A VDD GND B D C Y
*.PININFO A:I VDD:B GND:B B:I D:I C:I Y:O
XM9 Anot A GND GND sky130_fd_pr__nfet_01v8 L=0.15 W=2.52 nf=3
XM10 Anot A VDD VDD sky130_fd_pr__pfet_01v8 L=0.15 W=0.42 nf=1
XM4 Y Anot net3 GND sky130_fd_pr__nfet_01v8 L=0.15 W=5.04 nf=6
XM7 net1 Anot VDD VDD sky130_fd_pr__pfet_01v8 L=0.15 W=0.84 nf=1
XM1 Y Bnot net1 VDD sky130_fd_pr__pfet_01v8 L=0.15 W=0.84 nf=1
XM2 Y D net2 VDD sky130_fd_pr__pfet_01v8 L=0.15 W=0.84 nf=1
XM8 net2 C VDD VDD sky130_fd_pr__pfet_01v8 L=0.15 W=0.84 nf=1
XM11 Bnot B VDD VDD sky130_fd_pr__pfet_01v8 L=0.15 W=0.42 nf=1
XM12 Bnot B GND GND sky130_fd_pr__nfet_01v8 L=0.15 W=2.52 nf=3
XM3 net3 C GND GND sky130_fd_pr__nfet_01v8 L=0.15 W=5.04 nf=6
XM5 net3 D GND GND sky130_fd_pr__nfet_01v8 L=0.15 W=5.04 nf=6
XM6 Y Bnot net3 GND sky130_fd_pr__nfet_01v8 L=0.15 W=5.04 nf=6
.ends
