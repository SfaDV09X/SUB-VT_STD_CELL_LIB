* NGSPICE file created from nand2x4.ext - technology: sky130A

.subckt nand2x4 A B VDD GND Y
X0 Y.t7 B.t7 VDD.t5 VDD.t4 sky130_fd_pr__pfet_01v8 ad=0.1344 pd=1.16 as=0.1344 ps=1.16 w=0.84 l=0.22
X1 VDD.t3 B.t8 Y.t8 VDD.t2 sky130_fd_pr__pfet_01v8 ad=0.1428 pd=1.18 as=0.126 ps=1.14 w=0.84 l=0.22
X2 VDD.t7 B.t6 Y.t6 VDD.t6 sky130_fd_pr__pfet_01v8 ad=0.1344 pd=1.16 as=0.1344 ps=1.16 w=0.84 l=0.22
X3 Y.t0 A.t7 VDD.t17 VDD.t16 sky130_fd_pr__pfet_01v8 ad=0.1344 pd=1.16 as=0.1344 ps=1.16 w=0.84 l=0.22
X4 VDD.t23 A.t4 Y.t12 VDD.t22 sky130_fd_pr__pfet_01v8 ad=0.2394 pd=2.25 as=0.1176 ps=1.12 w=0.84 l=0.22
X5 VDD.t19 A.t6 Y.t1 VDD.t18 sky130_fd_pr__pfet_01v8 ad=0.1344 pd=1.16 as=0.1344 ps=1.16 w=0.84 l=0.22
X6 Y.t5 B.t5 VDD.t9 VDD.t8 sky130_fd_pr__pfet_01v8 ad=0.126 pd=1.14 as=0.1344 ps=1.16 w=0.84 l=0.22
X7 Y.t3 A.t3 a_282_84.t4 GND.t8 sky130_fd_pr__nfet_01v8 ad=0.1176 pd=1.12 as=0.126 ps=1.14 w=0.84 l=0.26
X8 a_282_84.t5 A.t2 Y.t2 GND.t9 sky130_fd_pr__nfet_01v8 ad=0.1176 pd=1.12 as=0.1176 ps=1.12 w=0.84 l=0.26
X9 a_282_84.t0 B.t3 GND.t5 GND.t4 sky130_fd_pr__nfet_01v8 ad=0.126 pd=1.14 as=0.2394 ps=2.25 w=0.84 l=0.26
X10 Y.t9 B.t9 VDD.t1 VDD.t0 sky130_fd_pr__pfet_01v8 ad=0.126 pd=1.14 as=0.2394 ps=2.25 w=0.84 l=0.22
X11 Y.t13 A.t5 VDD.t21 VDD.t20 sky130_fd_pr__pfet_01v8 ad=0.1176 pd=1.12 as=0.1176 ps=1.12 w=0.84 l=0.22
X12 Y.t14 A.t9 VDD.t13 VDD.t12 sky130_fd_pr__pfet_01v8 ad=0.1344 pd=1.16 as=0.1428 ps=1.18 w=0.84 l=0.22
X13 a_282_84.t2 B.t1 GND.t3 GND.t2 sky130_fd_pr__nfet_01v8 ad=0.1176 pd=1.12 as=0.1176 ps=1.12 w=0.84 l=0.26
X14 Y.t4 A.t1 a_282_84.t6 GND.t10 sky130_fd_pr__nfet_01v8 ad=0.1176 pd=1.12 as=0.1176 ps=1.12 w=0.84 l=0.26
X15 a_282_84.t7 A.t0 Y.t11 GND.t11 sky130_fd_pr__nfet_01v8 ad=0.1176 pd=1.12 as=0.1176 ps=1.12 w=0.84 l=0.26
X16 GND.t7 B.t0 a_282_84.t3 GND.t6 sky130_fd_pr__nfet_01v8 ad=0.2394 pd=2.25 as=0.1176 ps=1.12 w=0.84 l=0.26
X17 GND.t1 B.t2 a_282_84.t1 GND.t0 sky130_fd_pr__nfet_01v8 ad=0.1176 pd=1.12 as=0.1176 ps=1.12 w=0.84 l=0.26
X18 VDD.t11 B.t4 Y.t10 VDD.t10 sky130_fd_pr__pfet_01v8 ad=0.1176 pd=1.12 as=0.126 ps=1.14 w=0.84 l=0.22
X19 VDD.t15 A.t8 Y.t15 VDD.t14 sky130_fd_pr__pfet_01v8 ad=0.1344 pd=1.16 as=0.1344 ps=1.16 w=0.84 l=0.22
C0 Y B 0.23849f
C1 VDD A 0.646f
C2 B A 0.78727f
C3 VDD B 0.5764f
C4 Y A 0.50294f
C5 VDD Y 1.30453f
R0 Y.n12 Y.n10 307.599
R1 Y.n2 Y.n0 307.551
R2 Y.n2 Y.n1 307.072
R3 Y.n4 Y.n3 307.072
R4 Y.n6 Y.n5 307.072
R5 Y.n12 Y.n11 307.072
R6 Y.n9 Y.n7 127.686
R7 Y.n9 Y.n8 126.647
R8 Y.n1 Y.t5 37.5243
R9 Y.n3 Y.t0 37.5243
R10 Y.n3 Y.t1 37.5243
R11 Y.n5 Y.t7 37.5243
R12 Y.n5 Y.t6 37.5243
R13 Y.n11 Y.t14 37.5243
R14 Y.n11 Y.t15 37.5243
R15 Y.n10 Y.t8 37.5243
R16 Y.n0 Y.t13 32.8338
R17 Y.n0 Y.t12 32.8338
R18 Y.n1 Y.t10 32.8338
R19 Y.n10 Y.t9 32.8338
R20 Y.n7 Y.t4 20.0005
R21 Y.n7 Y.t11 20.0005
R22 Y.n8 Y.t3 20.0005
R23 Y.n8 Y.t2 20.0005
R24 Y.n12 Y.n9 10.2793
R25 Y.n6 Y.n4 0.519731
R26 Y.n4 Y.n2 0.519731
R27 Y Y.n6 0.315404
R28 Y Y.n12 0.204827
R29 A.n4 A.n0 252.794
R30 A.n1 A.t6 227.708
R31 A.n5 A.t8 227.708
R32 A.n0 A.t4 214.856
R33 A.n2 A.t0 195.643
R34 A.n6 A.t2 195.643
R35 A.n3 A.n2 171.212
R36 A.n7 A.n6 171.212
R37 A A.n7 162.284
R38 A.n4 A.n3 161.3
R39 A.n0 A.t5 124.882
R40 A.n1 A.t7 124.882
R41 A.n5 A.t9 124.882
R42 A.n2 A.t1 105.669
R43 A.n6 A.t3 105.669
R44 A.n3 A.n1 90.4851
R45 A.n7 A.n5 90.4851
R46 A A.n4 0.0557885
R47 B.n4 B.t6 227.708
R48 B.n0 B.t4 221.282
R49 B.n2 B.t9 221.282
R50 B.n5 B.t1 195.643
R51 B.n1 B.t0 189.244
R52 B.n3 B.t3 185.3
R53 B.n1 B.n0 178.121
R54 B.n6 B.n4 178.121
R55 B.n3 B.n2 174.178
R56 B B.n1 162.264
R57 B.n7 B.n3 162.089
R58 B.n7 B.n6 161.3
R59 B.n0 B.t5 124.882
R60 B.n4 B.t7 124.882
R61 B.n2 B.t8 124.882
R62 B.n5 B.t2 105.669
R63 B.n6 B.n5 83.5753
R64 B B.n7 0.0750192
R65 VDD.n9 VDD.t1 417.272
R66 VDD.n3 VDD.t23 414.945
R67 VDD.n3 VDD.n2 343.325
R68 VDD.n4 VDD.n1 343.325
R69 VDD.n5 VDD.n0 343.325
R70 VDD.n10 VDD.n7 343.325
R71 VDD.n9 VDD.n8 343.325
R72 VDD.t12 VDD.t2 240.725
R73 VDD.t14 VDD.t12 232.127
R74 VDD.t4 VDD.t14 232.127
R75 VDD.t6 VDD.t4 232.127
R76 VDD.t16 VDD.t18 232.127
R77 VDD.t18 VDD.t8 232.127
R78 VDD.t2 VDD.t0 223.53
R79 VDD.t8 VDD.t10 223.53
R80 VDD.t10 VDD.t20 214.933
R81 VDD.t20 VDD.t22 214.933
R82 VDD.n6 VDD.t16 137.558
R83 VDD.n6 VDD.t6 94.5706
R84 VDD.n8 VDD.t3 42.2148
R85 VDD.n10 VDD.n9 41.8914
R86 VDD.n5 VDD.n4 41.8914
R87 VDD.n4 VDD.n3 40.3399
R88 VDD.n11 VDD.n10 39.952
R89 VDD.n1 VDD.t19 37.5243
R90 VDD.n1 VDD.t9 37.5243
R91 VDD.n0 VDD.t7 37.5243
R92 VDD.n0 VDD.t17 37.5243
R93 VDD.n7 VDD.t15 37.5243
R94 VDD.n7 VDD.t5 37.5243
R95 VDD.n8 VDD.t13 37.5243
R96 VDD.n2 VDD.t11 32.8338
R97 VDD.n2 VDD.t21 32.8338
R98 VDD.n11 VDD.n6 18.5005
R99 VDD.n11 VDD.n5 1.93989
R100 VDD VDD.n11 1.43529
R101 GND.t8 GND.t4 1009.84
R102 GND.t9 GND.t8 973.771
R103 GND.t0 GND.t9 973.771
R104 GND.t2 GND.t0 973.771
R105 GND.t10 GND.t11 973.771
R106 GND.t11 GND.t6 973.771
R107 GND.n0 GND.t10 577.049
R108 GND.n0 GND.t2 396.721
R109 GND.n2 GND.t5 247.881
R110 GND.n3 GND.t7 228.1
R111 GND.n2 GND.n1 143.325
R112 GND.n3 GND.n0 58.5005
R113 GND.n1 GND.t1 20.0005
R114 GND.n1 GND.t3 20.0005
R115 GND.n3 GND.n2 19.0066
R116 GND GND.n3 1.43529
R117 a_282_84.n2 a_282_84.n0 136.359
R118 a_282_84.n5 a_282_84.n4 107.591
R119 a_282_84.n4 a_282_84.n3 107.072
R120 a_282_84.n2 a_282_84.n1 107.072
R121 a_282_84.n0 a_282_84.t0 22.8576
R122 a_282_84.n5 a_282_84.t7 20.0005
R123 a_282_84.t3 a_282_84.n5 20.0005
R124 a_282_84.n0 a_282_84.t4 20.0005
R125 a_282_84.n3 a_282_84.t2 20.0005
R126 a_282_84.n3 a_282_84.t6 20.0005
R127 a_282_84.n1 a_282_84.t5 20.0005
R128 a_282_84.n1 a_282_84.t1 20.0005
R129 a_282_84.n4 a_282_84.n2 0.519731
C6 Y GND 0.59696f
C7 A GND 0.88599f
C8 B GND 1.02832f
C9 VDD GND 2.81969f
C10 a_282_84.t7 GND 0.02255f ; **FLOATING
C11 a_282_84.t4 GND 0.02255f ; **FLOATING
C12 a_282_84.t0 GND 0.02578f ; **FLOATING
C13 a_282_84.n0 GND 0.06875f ; **FLOATING
C14 a_282_84.t1 GND 0.02255f ; **FLOATING
C15 a_282_84.t5 GND 0.02255f ; **FLOATING
C16 a_282_84.n1 GND 0.05162f ; **FLOATING
C17 a_282_84.n2 GND 0.36908f ; **FLOATING
C18 a_282_84.t6 GND 0.02255f ; **FLOATING
C19 a_282_84.t2 GND 0.02255f ; **FLOATING
C20 a_282_84.n3 GND 0.05162f ; **FLOATING
C21 a_282_84.n4 GND 0.27869f ; **FLOATING
C22 a_282_84.n5 GND 0.0522f ; **FLOATING
C23 a_282_84.t3 GND 0.02255f ; **FLOATING
C24 VDD.t17 GND 0.00605f ; **FLOATING
C25 VDD.t7 GND 0.00605f ; **FLOATING
C26 VDD.n0 GND 0.01386f ; **FLOATING
C27 VDD.t9 GND 0.00605f ; **FLOATING
C28 VDD.t19 GND 0.00605f ; **FLOATING
C29 VDD.n1 GND 0.01386f ; **FLOATING
C30 VDD.t21 GND 0.00529f ; **FLOATING
C31 VDD.t11 GND 0.00529f ; **FLOATING
C32 VDD.n2 GND 0.01235f ; **FLOATING
C33 VDD.t23 GND 0.02554f ; **FLOATING
C34 VDD.n3 GND 0.08246f ; **FLOATING
C35 VDD.n4 GND 0.0468f ; **FLOATING
C36 VDD.n5 GND 0.03209f ; **FLOATING
C37 VDD.t22 GND 0.24674f ; **FLOATING
C38 VDD.t20 GND 0.09949f ; **FLOATING
C39 VDD.t10 GND 0.10148f ; **FLOATING
C40 VDD.t8 GND 0.10546f ; **FLOATING
C41 VDD.t18 GND 0.10745f ; **FLOATING
C42 VDD.t16 GND 0.08556f ; **FLOATING
C43 VDD.t0 GND 0.24873f ; **FLOATING
C44 VDD.t2 GND 0.10745f ; **FLOATING
C45 VDD.t12 GND 0.10944f ; **FLOATING
C46 VDD.t14 GND 0.10745f ; **FLOATING
C47 VDD.t4 GND 0.10745f ; **FLOATING
C48 VDD.t6 GND 0.07561f ; **FLOATING
C49 VDD.n6 GND 0.14511f ; **FLOATING
C50 VDD.t5 GND 0.00605f ; **FLOATING
C51 VDD.t15 GND 0.00605f ; **FLOATING
C52 VDD.n7 GND 0.01386f ; **FLOATING
C53 VDD.t13 GND 0.00605f ; **FLOATING
C54 VDD.t3 GND 0.00681f ; **FLOATING
C55 VDD.n8 GND 0.01462f ; **FLOATING
C56 VDD.t1 GND 0.02584f ; **FLOATING
C57 VDD.n9 GND 0.08454f ; **FLOATING
C58 VDD.n10 GND 0.04665f ; **FLOATING
C59 VDD.n11 GND 0.2639f ; **FLOATING
C60 B.t4 GND 0.08401f ; **FLOATING
C61 B.t5 GND 0.06769f ; **FLOATING
C62 B.n0 GND 0.08582f ; **FLOATING
C63 B.t0 GND 0.10001f ; **FLOATING
C64 B.n1 GND 0.09014f ; **FLOATING
C65 B.t9 GND 0.08401f ; **FLOATING
C66 B.t8 GND 0.06769f ; **FLOATING
C67 B.n2 GND 0.08528f ; **FLOATING
C68 B.t3 GND 0.09934f ; **FLOATING
C69 B.n3 GND 0.09115f ; **FLOATING
C70 B.t6 GND 0.08486f ; **FLOATING
C71 B.t7 GND 0.06769f ; **FLOATING
C72 B.n4 GND 0.08608f ; **FLOATING
C73 B.t1 GND 0.09941f ; **FLOATING
C74 B.t2 GND 0.07999f ; **FLOATING
C75 B.n5 GND 0.07588f ; **FLOATING
C76 B.n6 GND 0.06405f ; **FLOATING
C77 B.n7 GND 0.21827f ; **FLOATING
C78 A.t4 GND 0.09006f ; **FLOATING
C79 A.t5 GND 0.07331f ; **FLOATING
C80 A.n0 GND 0.10481f ; **FLOATING
C81 A.t6 GND 0.09191f ; **FLOATING
C82 A.t7 GND 0.07331f ; **FLOATING
C83 A.n1 GND 0.07601f ; **FLOATING
C84 A.t0 GND 0.10767f ; **FLOATING
C85 A.t1 GND 0.08664f ; **FLOATING
C86 A.n2 GND 0.09945f ; **FLOATING
C87 A.n3 GND 0.06933f ; **FLOATING
C88 A.n4 GND 0.29811f ; **FLOATING
C89 A.t8 GND 0.09191f ; **FLOATING
C90 A.t9 GND 0.07331f ; **FLOATING
C91 A.n5 GND 0.07601f ; **FLOATING
C92 A.t2 GND 0.10767f ; **FLOATING
C93 A.t3 GND 0.08664f ; **FLOATING
C94 A.n6 GND 0.09945f ; **FLOATING
C95 A.n7 GND 0.0702f ; **FLOATING
C96 Y.t12 GND 0.02626f ; **FLOATING
C97 Y.t13 GND 0.02626f ; **FLOATING
C98 Y.n0 GND 0.05538f ; **FLOATING
C99 Y.t10 GND 0.02626f ; **FLOATING
C100 Y.t5 GND 0.03001f ; **FLOATING
C101 Y.n1 GND 0.05891f ; **FLOATING
C102 Y.n2 GND 0.32551f ; **FLOATING
C103 Y.t1 GND 0.03001f ; **FLOATING
C104 Y.t0 GND 0.03001f ; **FLOATING
C105 Y.n3 GND 0.06266f ; **FLOATING
C106 Y.n4 GND 0.18957f ; **FLOATING
C107 Y.t6 GND 0.03001f ; **FLOATING
C108 Y.t7 GND 0.03001f ; **FLOATING
C109 Y.n5 GND 0.06266f ; **FLOATING
C110 Y.n6 GND 0.1649f ; **FLOATING
C111 Y.t11 GND 0.02626f ; **FLOATING
C112 Y.t4 GND 0.02626f ; **FLOATING
C113 Y.n7 GND 0.06804f ; **FLOATING
C114 Y.t2 GND 0.02626f ; **FLOATING
C115 Y.t3 GND 0.02626f ; **FLOATING
C116 Y.n8 GND 0.06644f ; **FLOATING
C117 Y.n9 GND 0.56516f ; **FLOATING
C118 Y.t8 GND 0.03001f ; **FLOATING
C119 Y.t9 GND 0.02626f ; **FLOATING
C120 Y.n10 GND 0.05917f ; **FLOATING
C121 Y.t15 GND 0.03001f ; **FLOATING
C122 Y.t14 GND 0.03001f ; **FLOATING
C123 Y.n11 GND 0.06266f ; **FLOATING
C124 Y.n12 GND 0.47207f ; **FLOATING
.ends
