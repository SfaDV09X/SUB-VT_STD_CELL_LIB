* NGSPICE file created from inv1x4.ext - technology: sky130A

.subckt inv1x4 A Y VDD GND
X0 Y.t1 A.t0 GND.t1 GND.t0 sky130_fd_pr__nfet_01v8 ad=0.2394 pd=2.25 as=0.2394 ps=2.25 w=0.84 l=0.29
X1 VDD.t3 A.t1 Y.t0 VDD.t2 sky130_fd_pr__pfet_01v8 ad=0.2394 pd=2.25 as=0.1344 ps=1.16 w=0.84 l=0.21
X2 Y.t2 A.t2 VDD.t1 VDD.t0 sky130_fd_pr__pfet_01v8 ad=0.1344 pd=1.16 as=0.273 ps=2.33 w=0.84 l=0.21
C0 Y A 0.07889f
C1 VDD Y 0.19723f
C2 VDD A 0.21604f
R0 Y.n2 Y.n1 307.072
R1 Y Y.t1 152.371
R2 Y.n1 Y.t2 42.2148
R3 Y.n1 Y.t0 32.8338
R4 Y Y.n2 4.55579
R5 Y.n2 Y.n0 0.0557885
R6 A.n0 A.t1 233.655
R7 A.n1 A.n0 185.915
R8 A.n1 A.t0 179.504
R9 A A.n1 161.356
R10 A.n0 A.t2 130.829
R11 VDD.n1 VDD.t1 406.096
R12 VDD.n1 VDD.t3 396.714
R13 VDD.n0 VDD.t2 122.511
R14 VDD.n0 VDD.t0 105.317
R15 VDD.n1 VDD.n0 74.0005
R16 VDD VDD.n1 2.14696
R17 GND.n0 GND.t0 1573.13
R18 GND.n0 GND.t1 183.881
R19 GND GND.n0 2.14696
C3 Y GND 0.55885f
C4 A GND 0.33608f
C5 VDD GND 1.0858f
C6 VDD.t3 GND 0.0117f ; **FLOATING
C7 VDD.t2 GND 0.12182f ; **FLOATING
C8 VDD.t0 GND 0.12379f ; **FLOATING
C9 VDD.n0 GND 0.03862f ; **FLOATING
C10 VDD.t1 GND 0.01291f ; **FLOATING
C11 VDD.n1 GND 0.06011f ; **FLOATING
C12 A.t1 GND 0.04968f ; **FLOATING
C13 A.t2 GND 0.03974f ; **FLOATING
C14 A.n0 GND 0.05113f ; **FLOATING
C15 A.t0 GND 0.06913f ; **FLOATING
C16 A.n1 GND 0.05442f ; **FLOATING
C17 Y.n0 GND 0.00421f ; **FLOATING
C18 Y.t0 GND 0.00929f ; **FLOATING
C19 Y.t2 GND 0.01194f ; **FLOATING
C20 Y.n1 GND 0.02216f ; **FLOATING
C21 Y.n2 GND 0.03173f ; **FLOATING
C22 Y.t1 GND 0.04f ; **FLOATING
.ends
