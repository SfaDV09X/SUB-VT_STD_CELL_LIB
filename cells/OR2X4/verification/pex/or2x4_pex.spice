* NGSPICE file created from or2x4.ext - technology: sky130A

.subckt or2x4 A B VDD GND Y
X0 GND.t13 A.t0 a_101_564.t10 GND.t12 sky130_fd_pr__nfet_01v8 ad=0.1176 pd=1.12 as=0.1176 ps=1.12 w=0.84 l=0.26
X1 Y.t4 a_101_564.t13 GND.t17 GND.t16 sky130_fd_pr__nfet_01v8 ad=0.1176 pd=1.12 as=0.1176 ps=1.12 w=0.84 l=0.29
X2 Y.t0 a_101_564.t11 GND.t1 GND.t0 sky130_fd_pr__nfet_01v8 ad=0.2394 pd=2.25 as=0.1176 ps=1.12 w=0.84 l=0.29
X3 a_101_564.t7 B.t0 GND.t7 GND.t6 sky130_fd_pr__nfet_01v8 ad=0.1176 pd=1.12 as=0.1176 ps=1.12 w=0.84 l=0.26
X4 VDD.t20 a_101_564.t14 Y.t5 VDD.t19 sky130_fd_pr__pfet_01v8 ad=0.2394 pd=2.25 as=0.1176 ps=1.12 w=0.84 l=0.21
X5 VDD.t12 A.t5 a_198_564.t7 VDD.t11 sky130_fd_pr__pfet_01v8 ad=0.1428 pd=1.18 as=0.1512 ps=1.2 w=0.84 l=0.2
X6 a_198_564.t8 A.t4 VDD.t18 VDD.t17 sky130_fd_pr__pfet_01v8 ad=0.1428 pd=1.18 as=0.1428 ps=1.18 w=0.84 l=0.2
X7 VDD.t16 A.t7 a_198_564.t5 VDD.t15 sky130_fd_pr__pfet_01v8 ad=0.1176 pd=1.12 as=0.1176 ps=1.12 w=0.84 l=0.2
X8 a_198_564.t6 A.t6 VDD.t10 VDD.t9 sky130_fd_pr__pfet_01v8 ad=0.1176 pd=1.12 as=0.1176 ps=1.12 w=0.84 l=0.2
X9 a_198_564.t3 B.t7 a_101_564.t0 VDD.t0 sky130_fd_pr__pfet_01v8 ad=0.1176 pd=1.12 as=0.2394 ps=2.25 w=0.84 l=0.2
X10 a_101_564.t1 B.t6 a_198_564.t4 VDD.t1 sky130_fd_pr__pfet_01v8 ad=0.1302 pd=1.15 as=0.1176 ps=1.12 w=0.84 l=0.2
X11 Y.t7 a_101_564.t19 VDD.t24 VDD.t23 sky130_fd_pr__pfet_01v8 ad=0.1512 pd=1.2 as=0.147 ps=1.19 w=0.84 l=0.21
X12 a_101_564.t3 B.t4 a_198_564.t1 VDD.t3 sky130_fd_pr__pfet_01v8 ad=0.1428 pd=1.18 as=0.1428 ps=1.18 w=0.84 l=0.2
X13 VDD.t26 a_101_564.t16 Y.t8 VDD.t25 sky130_fd_pr__pfet_01v8 ad=0.1176 pd=1.12 as=0.1344 ps=1.16 w=0.84 l=0.21
X14 a_198_564.t2 B.t5 a_101_564.t2 VDD.t2 sky130_fd_pr__pfet_01v8 ad=0.1512 pd=1.2 as=0.1302 ps=1.15 w=0.84 l=0.2
X15 a_198_564.t0 B.t3 a_101_564.t4 VDD.t4 sky130_fd_pr__pfet_01v8 ad=0.1428 pd=1.18 as=0.1428 ps=1.18 w=0.84 l=0.2
X16 VDD.t6 a_101_564.t18 Y.t1 VDD.t5 sky130_fd_pr__pfet_01v8 ad=0.1512 pd=1.2 as=0.1512 ps=1.2 w=0.84 l=0.21
X17 GND.t9 A.t2 a_101_564.t8 GND.t8 sky130_fd_pr__nfet_01v8 ad=0.1176 pd=1.12 as=0.126 ps=1.14 w=0.84 l=0.26
X18 a_101_564.t9 A.t1 GND.t11 GND.t10 sky130_fd_pr__nfet_01v8 ad=0.1176 pd=1.12 as=0.1176 ps=1.12 w=0.84 l=0.26
X19 GND.t5 B.t1 a_101_564.t6 GND.t4 sky130_fd_pr__nfet_01v8 ad=0.1176 pd=1.12 as=0.1176 ps=1.12 w=0.84 l=0.26
X20 GND.t15 a_101_564.t12 Y.t3 GND.t14 sky130_fd_pr__nfet_01v8 ad=0.1176 pd=1.12 as=0.1176 ps=1.12 w=0.84 l=0.29
X21 VDD.t14 A.t3 a_198_564.t9 VDD.t13 sky130_fd_pr__pfet_01v8 ad=0.147 pd=1.19 as=0.1428 ps=1.18 w=0.84 l=0.2
X22 Y.t6 a_101_564.t17 VDD.t22 VDD.t21 sky130_fd_pr__pfet_01v8 ad=0.1344 pd=1.16 as=0.1512 ps=1.2 w=0.84 l=0.21
X23 a_101_564.t5 B.t2 GND.t3 GND.t2 sky130_fd_pr__nfet_01v8 ad=0.126 pd=1.14 as=0.2394 ps=2.25 w=0.84 l=0.26
X24 Y.t2 a_101_564.t15 VDD.t8 VDD.t7 sky130_fd_pr__pfet_01v8 ad=0.1176 pd=1.12 as=0.1176 ps=1.12 w=0.84 l=0.21
C0 B A 0.67172f
C1 Y A 0.01135f
C2 B VDD 0.41211f
C3 Y VDD 0.65974f
C4 B Y 0.0063f
C5 A VDD 0.53663f
R0 Y.n2 Y.n0 307.543
R1 Y.n4 Y.n3 307.289
R2 Y.n2 Y.n1 307.072
R3 Y.n7 Y.t0 146.922
R4 Y.n7 Y.n6 126.921
R5 Y.n1 Y.t6 42.2148
R6 Y.n3 Y.t7 42.2148
R7 Y.n3 Y.t1 42.2148
R8 Y.n0 Y.t2 32.8338
R9 Y.n0 Y.t5 32.8338
R10 Y.n1 Y.t8 32.8338
R11 Y.n6 Y.t4 20.0005
R12 Y.n6 Y.t3 20.0005
R13 Y Y.n7 5.72406
R14 Y Y.n5 4.55579
R15 Y.n5 Y.n2 0.274538
R16 Y.n5 Y.n4 0.0557885
R17 A.n0 A.t0 286.301
R18 A.n5 A.n1 255.268
R19 A.n2 A.t4 246.624
R20 A.n0 A.t3 230.594
R21 A.n1 A.t7 227.344
R22 A.n3 A.t1 195.643
R23 A.n4 A.n3 185.47
R24 A A.n0 162.264
R25 A.n5 A.n4 161.3
R26 A.n2 A.t5 137.37
R27 A.n1 A.t6 137.37
R28 A.n3 A.t2 105.669
R29 A.n4 A.n2 98.0602
R30 A A.n5 0.0750192
R31 B B.t7 489.046
R32 B.n0 B.t3 246.624
R33 B.n3 B.t6 236.983
R34 B.n1 B.t0 195.643
R35 B.n2 B.n0 194.46
R36 B.n4 B.t2 189.901
R37 B.n4 B.n3 189.624
R38 B.n5 B.n2 162.089
R39 B.n5 B.n4 161.3
R40 B.n0 B.t4 137.37
R41 B.n3 B.t5 137.37
R42 B.n1 B.t1 105.669
R43 B.n2 B.n1 89.0691
R44 B B.n5 0.185596
R45 VDD.n9 VDD.n8 423.228
R46 VDD.n3 VDD.t20 414.17
R47 VDD.n3 VDD.n2 343.325
R48 VDD.n4 VDD.n1 343.325
R49 VDD.n5 VDD.n0 343.325
R50 VDD.n9 VDD.n7 343.325
R51 VDD.t23 VDD.t5 245.024
R52 VDD.t5 VDD.t21 245.024
R53 VDD.t11 VDD.t2 240.725
R54 VDD.t13 VDD.t23 238.576
R55 VDD.t17 VDD.t11 232.127
R56 VDD.t3 VDD.t17 232.127
R57 VDD.t4 VDD.t13 232.127
R58 VDD.t21 VDD.t25 227.828
R59 VDD.t2 VDD.t1 219.232
R60 VDD.t25 VDD.t7 210.633
R61 VDD.t7 VDD.t19 210.633
R62 VDD.t15 VDD.t0 206.335
R63 VDD.t9 VDD.t15 206.335
R64 VDD.t1 VDD.t9 206.335
R65 VDD.n6 VDD.t3 150.452
R66 VDD.n6 VDD.t4 81.6747
R67 VDD.n10 VDD.n9 44.9944
R68 VDD.n5 VDD.n4 44.2187
R69 VDD.n1 VDD.t6 42.2148
R70 VDD.n1 VDD.t22 42.2148
R71 VDD.n0 VDD.t24 42.2148
R72 VDD.n4 VDD.n3 41.1157
R73 VDD.n0 VDD.t14 39.8695
R74 VDD.n7 VDD.t12 39.8695
R75 VDD.n7 VDD.t18 39.8695
R76 VDD.n10 VDD.n5 38.7884
R77 VDD.n2 VDD.t26 32.8338
R78 VDD.n2 VDD.t8 32.8338
R79 VDD.n8 VDD.t16 32.8338
R80 VDD.n8 VDD.t10 32.8338
R81 VDD.n10 VDD.n6 13.7042
R82 VDD VDD.n10 1.61729
R83 GND.t16 GND.t14 1027.87
R84 GND.t14 GND.t0 1027.87
R85 GND.t8 GND.t2 1009.84
R86 GND.t12 GND.t16 1000.82
R87 GND.t10 GND.t8 973.771
R88 GND.t4 GND.t10 973.771
R89 GND.t6 GND.t12 973.771
R90 GND.n3 GND.t4 631.149
R91 GND.n3 GND.t6 342.623
R92 GND.n6 GND.t3 205.99
R93 GND.n2 GND.n1 187.542
R94 GND.n6 GND.n5 143.325
R95 GND.n7 GND.n4 143.325
R96 GND.n2 GND.n0 143.325
R97 GND.n8 GND.n3 43.3338
R98 GND.n7 GND.n6 41.8914
R99 GND.n8 GND.n2 38.7884
R100 GND.n5 GND.t9 20.0005
R101 GND.n5 GND.t11 20.0005
R102 GND.n4 GND.t5 20.0005
R103 GND.n4 GND.t7 20.0005
R104 GND.n0 GND.t13 20.0005
R105 GND.n0 GND.t17 20.0005
R106 GND.n1 GND.t15 20.0005
R107 GND.n1 GND.t1 20.0005
R108 GND.n8 GND.n7 3.10353
R109 GND GND.n8 1.61729
R110 a_198_564.n6 a_198_564.n0 327.166
R111 a_198_564.n3 a_198_564.n1 327.11
R112 a_198_564.n7 a_198_564.n6 326.647
R113 a_198_564.n5 a_198_564.n4 326.647
R114 a_198_564.n3 a_198_564.n2 326.647
R115 a_198_564.n4 a_198_564.t2 44.56
R116 a_198_564.t8 a_198_564.n7 39.8695
R117 a_198_564.n7 a_198_564.t1 39.8695
R118 a_198_564.n0 a_198_564.t0 39.8695
R119 a_198_564.n0 a_198_564.t9 39.8695
R120 a_198_564.n4 a_198_564.t7 39.8695
R121 a_198_564.n2 a_198_564.t6 32.8338
R122 a_198_564.n2 a_198_564.t4 32.8338
R123 a_198_564.n1 a_198_564.t3 32.8338
R124 a_198_564.n1 a_198_564.t5 32.8338
R125 a_198_564.n6 a_198_564.n5 0.519731
R126 a_198_564.n5 a_198_564.n3 0.5005
R127 a_101_564.n1 a_101_564.t0 340.827
R128 a_101_564.n15 a_101_564.n14 307.849
R129 a_101_564.n1 a_101_564.n0 307.072
R130 a_101_564.n5 a_101_564.t19 246.51
R131 a_101_564.n2 a_101_564.t14 243.296
R132 a_101_564.n6 a_101_564.t11 215.774
R133 a_101_564.n6 a_101_564.t13 215.774
R134 a_101_564.n7 a_101_564.n5 181.532
R135 a_101_564.n9 a_101_564.n7 171.413
R136 a_101_564.n4 a_101_564.n3 147.814
R137 a_101_564.n5 a_101_564.n4 138.173
R138 a_101_564.n3 a_101_564.n2 134.96
R139 a_101_564.n5 a_101_564.t18 130.829
R140 a_101_564.n9 a_101_564.n8 107.072
R141 a_101_564.n11 a_101_564.n10 107.072
R142 a_101_564.n13 a_101_564.n12 107.072
R143 a_101_564.n4 a_101_564.t17 96.4005
R144 a_101_564.n3 a_101_564.t16 96.4005
R145 a_101_564.n2 a_101_564.t15 96.4005
R146 a_101_564.n6 a_101_564.t12 69.8074
R147 a_101_564.n7 a_101_564.n6 67.9187
R148 a_101_564.n15 a_101_564.t3 39.8695
R149 a_101_564.t4 a_101_564.n15 39.8695
R150 a_101_564.n0 a_101_564.t2 39.8695
R151 a_101_564.n0 a_101_564.t1 32.8338
R152 a_101_564.n12 a_101_564.t5 22.8576
R153 a_101_564.n8 a_101_564.t7 20.0005
R154 a_101_564.n8 a_101_564.t10 20.0005
R155 a_101_564.n10 a_101_564.t9 20.0005
R156 a_101_564.n10 a_101_564.t6 20.0005
R157 a_101_564.n12 a_101_564.t8 20.0005
R158 a_101_564.n14 a_101_564.n13 10.087
R159 a_101_564.n13 a_101_564.n11 0.519731
R160 a_101_564.n11 a_101_564.n9 0.519731
R161 a_101_564.n14 a_101_564.n1 0.269731
C6 Y GND 0.80809f
C7 A GND 0.79948f
C8 B GND 1.002f
C9 VDD GND 3.62893f
C10 a_101_564.t3 GND 0.02344f ; **FLOATING
C11 a_101_564.t0 GND 0.07503f ; **FLOATING
C12 a_101_564.t2 GND 0.02344f ; **FLOATING
C13 a_101_564.t1 GND 0.01931f ; **FLOATING
C14 a_101_564.n0 GND 0.04469f ; **FLOATING
C15 a_101_564.n1 GND 0.30132f ; **FLOATING
C16 a_101_564.t19 GND 0.07338f ; **FLOATING
C17 a_101_564.t17 GND 0.0524f ; **FLOATING
C18 a_101_564.t16 GND 0.0524f ; **FLOATING
C19 a_101_564.t15 GND 0.0524f ; **FLOATING
C20 a_101_564.t14 GND 0.07323f ; **FLOATING
C21 a_101_564.n2 GND 0.05982f ; **FLOATING
C22 a_101_564.n3 GND 0.04475f ; **FLOATING
C23 a_101_564.n4 GND 0.04465f ; **FLOATING
C24 a_101_564.t18 GND 0.05757f ; **FLOATING
C25 a_101_564.n5 GND 0.08507f ; **FLOATING
C26 a_101_564.t12 GND 0.07236f ; **FLOATING
C27 a_101_564.t11 GND 0.10436f ; **FLOATING
C28 a_101_564.t13 GND 0.10436f ; **FLOATING
C29 a_101_564.n6 GND 0.09928f ; **FLOATING
C30 a_101_564.n7 GND 0.06168f ; **FLOATING
C31 a_101_564.t10 GND 0.01931f ; **FLOATING
C32 a_101_564.t7 GND 0.01931f ; **FLOATING
C33 a_101_564.n8 GND 0.04418f ; **FLOATING
C34 a_101_564.n9 GND 0.36542f ; **FLOATING
C35 a_101_564.t6 GND 0.01931f ; **FLOATING
C36 a_101_564.t9 GND 0.01931f ; **FLOATING
C37 a_101_564.n10 GND 0.04418f ; **FLOATING
C38 a_101_564.n11 GND 0.13574f ; **FLOATING
C39 a_101_564.t8 GND 0.01931f ; **FLOATING
C40 a_101_564.t5 GND 0.02206f ; **FLOATING
C41 a_101_564.n12 GND 0.04694f ; **FLOATING
C42 a_101_564.n13 GND 0.21342f ; **FLOATING
C43 a_101_564.n14 GND 0.33281f ; **FLOATING
C44 a_101_564.n15 GND 0.04916f ; **FLOATING
C45 a_101_564.t4 GND 0.02344f ; **FLOATING
C46 a_198_564.t1 GND 0.04379f ; **FLOATING
C47 a_198_564.t9 GND 0.04379f ; **FLOATING
C48 a_198_564.t0 GND 0.04379f ; **FLOATING
C49 a_198_564.n0 GND 0.09531f ; **FLOATING
C50 a_198_564.t5 GND 0.03606f ; **FLOATING
C51 a_198_564.t3 GND 0.03606f ; **FLOATING
C52 a_198_564.n1 GND 0.0798f ; **FLOATING
C53 a_198_564.t4 GND 0.03606f ; **FLOATING
C54 a_198_564.t6 GND 0.03606f ; **FLOATING
C55 a_198_564.n2 GND 0.07954f ; **FLOATING
C56 a_198_564.n3 GND 0.42995f ; **FLOATING
C57 a_198_564.t7 GND 0.04379f ; **FLOATING
C58 a_198_564.t2 GND 0.04894f ; **FLOATING
C59 a_198_564.n4 GND 0.10015f ; **FLOATING
C60 a_198_564.n5 GND 0.25338f ; **FLOATING
C61 a_198_564.n6 GND 0.45223f ; **FLOATING
C62 a_198_564.n7 GND 0.09499f ; **FLOATING
C63 a_198_564.t8 GND 0.04379f ; **FLOATING
C64 VDD.t24 GND 0.00719f ; **FLOATING
C65 VDD.t14 GND 0.00679f ; **FLOATING
C66 VDD.n0 GND 0.01584f ; **FLOATING
C67 VDD.t22 GND 0.00719f ; **FLOATING
C68 VDD.t6 GND 0.00719f ; **FLOATING
C69 VDD.n1 GND 0.01624f ; **FLOATING
C70 VDD.t8 GND 0.00559f ; **FLOATING
C71 VDD.t26 GND 0.00559f ; **FLOATING
C72 VDD.n2 GND 0.01304f ; **FLOATING
C73 VDD.t20 GND 0.02728f ; **FLOATING
C74 VDD.n3 GND 0.09086f ; **FLOATING
C75 VDD.n4 GND 0.05068f ; **FLOATING
C76 VDD.n5 GND 0.04974f ; **FLOATING
C77 VDD.t19 GND 0.28789f ; **FLOATING
C78 VDD.t7 GND 0.10297f ; **FLOATING
C79 VDD.t25 GND 0.10717f ; **FLOATING
C80 VDD.t21 GND 0.11558f ; **FLOATING
C81 VDD.t5 GND 0.11978f ; **FLOATING
C82 VDD.t23 GND 0.1182f ; **FLOATING
C83 VDD.t13 GND 0.11505f ; **FLOATING
C84 VDD.t4 GND 0.0767f ; **FLOATING
C85 VDD.t0 GND 0.28579f ; **FLOATING
C86 VDD.t15 GND 0.10087f ; **FLOATING
C87 VDD.t9 GND 0.10087f ; **FLOATING
C88 VDD.t1 GND 0.10402f ; **FLOATING
C89 VDD.t2 GND 0.11242f ; **FLOATING
C90 VDD.t11 GND 0.11558f ; **FLOATING
C91 VDD.t17 GND 0.11347f ; **FLOATING
C92 VDD.t3 GND 0.09351f ; **FLOATING
C93 VDD.n6 GND 0.18496f ; **FLOATING
C94 VDD.t18 GND 0.00679f ; **FLOATING
C95 VDD.t12 GND 0.00679f ; **FLOATING
C96 VDD.n7 GND 0.01544f ; **FLOATING
C97 VDD.t10 GND 0.00559f ; **FLOATING
C98 VDD.t16 GND 0.00559f ; **FLOATING
C99 VDD.n8 GND 0.03049f ; **FLOATING
C100 VDD.n9 GND 0.14165f ; **FLOATING
C101 VDD.n10 GND 0.41582f ; **FLOATING
C102 B.t3 GND 0.07658f ; **FLOATING
C103 B.t4 GND 0.06084f ; **FLOATING
C104 B.n0 GND 0.07959f ; **FLOATING
C105 B.t0 GND 0.0983f ; **FLOATING
C106 B.t1 GND 0.0791f ; **FLOATING
C107 B.n1 GND 0.07411f ; **FLOATING
C108 B.n2 GND 0.06128f ; **FLOATING
C109 B.t6 GND 0.07543f ; **FLOATING
C110 B.t5 GND 0.06084f ; **FLOATING
C111 B.n3 GND 0.07855f ; **FLOATING
C112 B.t2 GND 0.09843f ; **FLOATING
C113 B.n4 GND 0.08588f ; **FLOATING
C114 B.n5 GND 0.22672f ; **FLOATING
C115 B.t7 GND 0.11544f ; **FLOATING
C116 A.t3 GND 0.08793f ; **FLOATING
C117 A.t0 GND 0.1347f ; **FLOATING
C118 A.n0 GND 0.12253f ; **FLOATING
C119 A.t7 GND 0.08662f ; **FLOATING
C120 A.t6 GND 0.07097f ; **FLOATING
C121 A.n1 GND 0.10523f ; **FLOATING
C122 A.t4 GND 0.08933f ; **FLOATING
C123 A.t5 GND 0.07097f ; **FLOATING
C124 A.n2 GND 0.07625f ; **FLOATING
C125 A.t1 GND 0.11467f ; **FLOATING
C126 A.t2 GND 0.09227f ; **FLOATING
C127 A.n3 GND 0.10312f ; **FLOATING
C128 A.n4 GND 0.07078f ; **FLOATING
C129 A.n5 GND 0.25942f ; **FLOATING
C130 Y.t5 GND 0.01785f ; **FLOATING
C131 Y.t2 GND 0.01785f ; **FLOATING
C132 Y.n0 GND 0.03764f ; **FLOATING
C133 Y.t8 GND 0.01785f ; **FLOATING
C134 Y.t6 GND 0.02295f ; **FLOATING
C135 Y.n1 GND 0.0426f ; **FLOATING
C136 Y.n2 GND 0.19958f ; **FLOATING
C137 Y.t1 GND 0.02295f ; **FLOATING
C138 Y.t7 GND 0.02295f ; **FLOATING
C139 Y.n3 GND 0.04775f ; **FLOATING
C140 Y.n4 GND 0.09665f ; **FLOATING
C141 Y.n5 GND 0.02724f ; **FLOATING
C142 Y.t0 GND 0.07352f ; **FLOATING
C143 Y.t3 GND 0.01785f ; **FLOATING
C144 Y.t4 GND 0.01785f ; **FLOATING
C145 Y.n6 GND 0.04532f ; **FLOATING
C146 Y.n7 GND 0.2198f ; **FLOATING
.ends
