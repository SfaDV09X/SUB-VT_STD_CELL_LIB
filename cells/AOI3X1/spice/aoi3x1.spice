** sch_path: /foss/designs/aoi3x1.sch
.subckt aoi3x1 VDD GND A B C Y
*.PININFO VDD:B GND:B A:I B:I C:I Y:O
XM2 net2 A VDD VDD sky130_fd_pr__pfet_01v8 L=0.15 W=0.84 nf=1
XM3 net2 B VDD VDD sky130_fd_pr__pfet_01v8 L=0.15 W=0.84 nf=1
XM4 Y A net1 GND sky130_fd_pr__nfet_01v8 L=0.15 W=5.04 nf=6
XM5 Y C GND GND sky130_fd_pr__nfet_01v8 L=0.15 W=2.52 nf=3
XM1 Y C net2 VDD sky130_fd_pr__pfet_01v8 L=0.15 W=0.84 nf=1
XM6 net1 B GND GND sky130_fd_pr__nfet_01v8 L=0.15 W=5.04 nf=6
.ends
