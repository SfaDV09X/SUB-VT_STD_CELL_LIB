* NGSPICE file created from dffx4.ext - technology: sky130A

.subckt dffx4 VDD GND CLK D Q QB
X0 a_204_564.t0 CLK.t3 GND.t16 GND.t15 sky130_fd_pr__nfet_01v8 ad=0.1176 pd=1.12 as=0.2394 ps=2.25 w=0.84 l=0.29
X1 QB.t1 a_1647_564.t8 VDD.t9 VDD.t8 sky130_fd_pr__pfet_01v8 ad=0.1176 pd=1.12 as=0.1344 ps=1.16 w=0.84 l=0.21
X2 Q.t2 QB.t7 GND.t3 GND.t2 sky130_fd_pr__nfet_01v8 ad=0.1176 pd=1.12 as=0.2394 ps=2.25 w=0.84 l=0.29
X3 a_204_564.t4 CLK.t8 VDD.t32 VDD.t31 sky130_fd_pr__pfet_01v8 ad=0.1176 pd=1.12 as=0.1344 ps=1.16 w=0.84 l=0.21
X4 GND.t11 a_1647_564.t5 QB.t5 GND.t10 sky130_fd_pr__nfet_01v8 ad=0.2394 pd=2.25 as=0.1176 ps=1.12 w=0.84 l=0.29
X5 D.t0 CLK.t6 a_633_564.t1 VDD.t33 sky130_fd_pr__pfet_01v8 ad=0.1638 pd=1.23 as=0.294 ps=2.38 w=0.84 l=0.19
X6 a_1647_564.t1 a_204_564.t8 a_633_84.t3 VDD.t24 sky130_fd_pr__pfet_01v8 ad=0.1365 pd=1.165 as=0.1638 ps=1.23 w=0.84 l=0.19
X7 a_204_564.t2 CLK.t10 VDD.t26 VDD.t25 sky130_fd_pr__pfet_01v8 ad=0.1512 pd=1.2 as=0.273 ps=2.33 w=0.84 l=0.21
X8 QB.t3 a_1647_564.t10 VDD.t13 VDD.t12 sky130_fd_pr__pfet_01v8 ad=0.1512 pd=1.2 as=0.273 ps=2.33 w=0.84 l=0.21
X9 a_1049_519.t1 a_633_564.t7 VDD.t17 VDD.t16 sky130_fd_pr__pfet_01v8 ad=0.1344 pd=1.16 as=0.273 ps=2.33 w=0.84 l=0.21
X10 a_633_84.t1 a_1049_519.t4 VDD.t21 VDD.t20 sky130_fd_pr__pfet_01v8 ad=0.273 pd=2.33 as=0.1491 ps=1.195 w=0.84 l=0.21
X11 VDD.t30 CLK.t9 a_204_564.t3 VDD.t29 sky130_fd_pr__pfet_01v8 ad=0.1344 pd=1.16 as=0.1512 ps=1.2 w=0.84 l=0.21
X12 VDD.t23 a_1049_519.t5 a_633_84.t2 VDD.t22 sky130_fd_pr__pfet_01v8 ad=0.1491 pd=1.195 as=0.1323 ps=1.155 w=0.84 l=0.21
X13 VDD.t11 a_1647_564.t9 QB.t2 VDD.t10 sky130_fd_pr__pfet_01v8 ad=0.1344 pd=1.16 as=0.1512 ps=1.2 w=0.84 l=0.21
X14 GND.t1 a_1049_519.t3 a_633_84.t0 GND.t0 sky130_fd_pr__nfet_01v8 ad=0.2394 pd=2.25 as=0.2394 ps=2.25 w=0.84 l=0.29
X15 Q.t5 CLK.t4 a_1647_564.t2 VDD.t35 sky130_fd_pr__pfet_01v8 ad=0.1323 pd=1.155 as=0.1365 ps=1.165 w=0.84 l=0.32
X16 GND.t5 QB.t6 Q.t3 GND.t4 sky130_fd_pr__nfet_01v8 ad=0.2394 pd=2.25 as=0.1176 ps=1.12 w=0.84 l=0.29
X17 Q.t4 QB.t8 VDD.t7 VDD.t6 sky130_fd_pr__pfet_01v8 ad=0.2394 pd=2.25 as=0.1344 ps=1.16 w=0.84 l=0.21
X18 VDD.t19 a_1647_564.t7 QB.t4 VDD.t18 sky130_fd_pr__pfet_01v8 ad=0.2394 pd=2.25 as=0.1176 ps=1.12 w=0.84 l=0.21
X19 VDD.t28 CLK.t7 a_204_564.t5 VDD.t27 sky130_fd_pr__pfet_01v8 ad=0.2394 pd=2.25 as=0.1176 ps=1.12 w=0.84 l=0.21
X20 Q.t0 QB.t10 VDD.t3 VDD.t2 sky130_fd_pr__pfet_01v8 ad=0.1512 pd=1.2 as=0.1491 ps=1.195 w=0.84 l=0.21
X21 a_1049_519.t0 a_633_564.t5 GND.t9 GND.t8 sky130_fd_pr__nfet_01v8 ad=0.2394 pd=2.25 as=0.2394 ps=2.25 w=0.84 l=0.29
X22 VDD.t1 QB.t11 Q.t1 VDD.t0 sky130_fd_pr__pfet_01v8 ad=0.1491 pd=1.195 as=0.1323 ps=1.155 w=0.84 l=0.21
X23 a_633_564.t0 CLK.t1 a_633_84.t5 GND.t17 sky130_fd_pr__nfet_01v8 ad=0.1197 pd=1.41 as=0.1197 ps=1.41 w=0.42 l=0.32
X24 a_633_564.t3 a_204_564.t7 D.t2 GND.t19 sky130_fd_pr__nfet_01v8 ad=0.294 pd=2.38 as=0.294 ps=2.38 w=0.84 l=0.19
X25 a_633_564.t2 CLK.t5 D.t1 VDD.t34 sky130_fd_pr__pfet_01v8 ad=0.1365 pd=1.165 as=0.1638 ps=1.23 w=0.84 l=0.19
X26 VDD.t5 QB.t9 Q.t6 VDD.t4 sky130_fd_pr__pfet_01v8 ad=0.1344 pd=1.16 as=0.1512 ps=1.2 w=0.84 l=0.21
X27 a_633_84.t6 a_204_564.t9 a_1647_564.t4 VDD.t36 sky130_fd_pr__pfet_01v8 ad=0.1638 pd=1.23 as=0.294 ps=2.38 w=0.84 l=0.19
X28 GND.t14 CLK.t2 a_204_564.t1 GND.t13 sky130_fd_pr__nfet_01v8 ad=0.2394 pd=2.25 as=0.1176 ps=1.12 w=0.84 l=0.29
X29 QB.t0 a_1647_564.t6 GND.t7 GND.t6 sky130_fd_pr__nfet_01v8 ad=0.1176 pd=1.12 as=0.2394 ps=2.25 w=0.84 l=0.29
X30 a_633_84.t7 a_204_564.t10 a_633_564.t4 VDD.t37 sky130_fd_pr__pfet_01v8 ad=0.1323 pd=1.155 as=0.1365 ps=1.165 w=0.84 l=0.32
X31 a_1647_564.t0 a_204_564.t6 Q.t7 GND.t12 sky130_fd_pr__nfet_01v8 ad=0.1197 pd=1.41 as=0.1197 ps=1.41 w=0.42 l=0.32
X32 a_1647_564.t3 CLK.t0 a_633_84.t4 GND.t18 sky130_fd_pr__nfet_01v8 ad=0.294 pd=2.38 as=0.294 ps=2.38 w=0.84 l=0.19
X33 VDD.t15 a_633_564.t6 a_1049_519.t2 VDD.t14 sky130_fd_pr__pfet_01v8 ad=0.2394 pd=2.25 as=0.1344 ps=1.16 w=0.84 l=0.21
C0 VDD QB 0.8751f
C1 Q QB 0.2748f
C2 D CLK 0.15354f
C3 VDD CLK 0.79127f
C4 Q CLK 0.23765f
C5 QB CLK 0.04766f
C6 D VDD 0.04402f
C7 VDD Q 0.58441f
R0 Q.n1 Q.t4 340.414
R1 Q.n1 Q.n0 307.072
R2 Q.n3 Q.n2 307.072
R3 Q Q.t7 265.221
R4 Q.n5 Q.n4 132.076
R5 Q.n0 Q.t0 42.2148
R6 Q.n0 Q.t6 42.2148
R7 Q.n2 Q.t1 41.0422
R8 Q.n2 Q.t5 32.8338
R9 Q.n4 Q.t2 20.0005
R10 Q.n4 Q.t3 20.0005
R11 Q.n5 Q.n3 5.39473
R12 Q Q.n5 4.70002
R13 Q.n3 Q.n1 0.543769
R14 D D.n0 307.151
R15 D D.t2 166.403
R16 D.n0 D.t0 48.0779
R17 D.n0 D.t1 43.3874
R18 QB.n2 QB.n0 307.58
R19 QB.n2 QB.n1 307.072
R20 QB.n5 QB.t8 256.149
R21 QB.n6 QB.t11 244.903
R22 QB.n7 QB.t6 184.712
R23 QB.n8 QB.n7 172.194
R24 QB QB.n8 162.161
R25 QB.n6 QB.n5 138.173
R26 QB.n6 QB.t10 130.829
R27 QB.n4 QB.n3 112.206
R28 QB.n5 QB.t9 96.4005
R29 QB.n7 QB.t7 94.7384
R30 QB.n8 QB.n6 89.7234
R31 QB.n1 QB.t3 42.2148
R32 QB.n1 QB.t2 42.2148
R33 QB.n0 QB.t1 32.8338
R34 QB.n0 QB.t4 32.8338
R35 QB.n3 QB.t0 20.0005
R36 QB.n3 QB.t5 20.0005
R37 QB.n4 QB.n2 4.95242
R38 QB QB.n4 4.82983
R39 CLK.n0 CLK.t4 276.692
R40 CLK.n1 CLK.t5 269.921
R41 CLK.n3 CLK.t7 243.296
R42 CLK.n0 CLK.t0 236.619
R43 CLK.n2 CLK.t1 207.085
R44 CLK.n2 CLK.n1 203.875
R45 CLK.n7 CLK.n5 185.915
R46 CLK.n6 CLK.t2 184.712
R47 CLK CLK.n0 173.736
R48 CLK.n8 CLK.n7 162.452
R49 CLK.n8 CLK.n2 161.445
R50 CLK.n4 CLK.n3 147.814
R51 CLK.n1 CLK.t6 144.601
R52 CLK.n5 CLK.n4 138.173
R53 CLK.n5 CLK.t10 130.829
R54 CLK.n4 CLK.t9 96.4005
R55 CLK.n3 CLK.t8 96.4005
R56 CLK.n6 CLK.t3 94.7384
R57 CLK.n7 CLK.n6 84.766
R58 CLK CLK.n8 9.47406
R59 VDD.t16 VDD.t20 485.748
R60 VDD.t33 VDD.t27 475
R61 VDD.t6 VDD.t12 468.553
R62 VDD.n10 VDD.t26 429.757
R63 VDD.n3 VDD.t19 414.17
R64 VDD.n4 VDD.t13 385.538
R65 VDD.n13 VDD.t17 385.538
R66 VDD.n11 VDD.t28 376.158
R67 VDD.n14 VDD.t15 376.158
R68 VDD.n7 VDD.t36 369.683
R69 VDD.n3 VDD.n2 343.325
R70 VDD.n5 VDD.n1 343.325
R71 VDD.n6 VDD.n0 343.325
R72 VDD.n12 VDD.n8 343.325
R73 VDD.n10 VDD.n9 343.325
R74 VDD.t34 VDD.t33 249.321
R75 VDD.t37 VDD.t34 249.321
R76 VDD.t22 VDD.t37 249.321
R77 VDD.t36 VDD.t24 249.321
R78 VDD.t24 VDD.t35 249.321
R79 VDD.t35 VDD.t0 249.321
R80 VDD.t29 VDD.t25 245.024
R81 VDD.t2 VDD.t4 245.024
R82 VDD.t12 VDD.t10 245.024
R83 VDD.t20 VDD.t22 242.874
R84 VDD.t0 VDD.t2 242.874
R85 VDD.t31 VDD.t29 227.828
R86 VDD.t14 VDD.t16 227.828
R87 VDD.t4 VDD.t6 227.828
R88 VDD.t10 VDD.t8 227.828
R89 VDD.t27 VDD.t31 210.633
R90 VDD.t8 VDD.t18 210.633
R91 VDD.n12 VDD.n11 111.71
R92 VDD.n14 VDD.n6 111.71
R93 VDD.n7 VDD.t14 105.317
R94 VDD.n6 VDD.n5 44.2187
R95 VDD.n4 VDD.n3 44.2187
R96 VDD.n13 VDD.n12 43.8308
R97 VDD.n2 VDD.t11 42.2148
R98 VDD.n1 VDD.t5 42.2148
R99 VDD.n0 VDD.t3 42.2148
R100 VDD.n8 VDD.t21 42.2148
R101 VDD.n9 VDD.t30 42.2148
R102 VDD.n14 VDD.n13 41.1157
R103 VDD.n0 VDD.t1 41.0422
R104 VDD.n8 VDD.t23 41.0422
R105 VDD.n5 VDD.n4 40.7278
R106 VDD.n11 VDD.n10 38.0126
R107 VDD.n2 VDD.t9 32.8338
R108 VDD.n1 VDD.t7 32.8338
R109 VDD.n9 VDD.t32 32.8338
R110 VDD.n14 VDD.n7 8.40959
R111 VDD VDD.n14 2.24537
R112 GND.t17 GND.t13 3831.97
R113 GND.t4 GND.t6 2921.31
R114 GND.t19 GND.t17 2091.8
R115 GND.t12 GND.t18 2091.8
R116 GND.t0 GND.t19 2064.75
R117 GND.t18 GND.t2 2064.75
R118 GND.t8 GND.t0 2037.7
R119 GND.n3 GND.t12 1550.82
R120 GND.n3 GND.t8 1397.54
R121 GND.t13 GND.t15 1027.87
R122 GND.t2 GND.t4 1027.87
R123 GND.t6 GND.t10 1027.87
R124 GND.n4 GND.t16 207.542
R125 GND.n0 GND.t11 207.542
R126 GND.n5 GND.n4 171.831
R127 GND.n4 GND.t14 163.325
R128 GND.n5 GND.t1 163.325
R129 GND.n6 GND.t9 163.325
R130 GND.n2 GND.t3 163.325
R131 GND.n1 GND.t5 163.325
R132 GND.n0 GND.t7 163.325
R133 GND.n7 GND.n2 111.71
R134 GND.n2 GND.n1 44.2187
R135 GND.n7 GND.n6 41.1157
R136 GND.n1 GND.n0 40.7278
R137 GND.n7 GND.n3 26.5914
R138 GND.n6 GND.n5 21.7217
R139 GND GND.n7 2.24537
R140 a_633_84.t1 a_633_84.n5 368.861
R141 a_633_84.n5 a_633_84.n0 327.985
R142 a_633_84.n4 a_633_84.n3 311.841
R143 a_633_84.n1 a_633_84.t5 253.643
R144 a_633_84.n2 a_633_84.t4 162.506
R145 a_633_84.n1 a_633_84.t0 127.072
R146 a_633_84.n0 a_633_84.t6 48.0779
R147 a_633_84.n0 a_633_84.t3 43.3874
R148 a_633_84.n3 a_633_84.t2 41.0422
R149 a_633_84.n3 a_633_84.t7 32.8338
R150 a_633_84.n5 a_633_84.n4 4.96685
R151 a_633_84.n2 a_633_84.n1 4.5005
R152 a_633_84.n4 a_633_84.n2 1.08704
R153 a_1647_564.n7 a_1647_564.t4 355.437
R154 a_1647_564.n8 a_1647_564.n7 307.341
R155 a_1647_564.n6 a_1647_564.t0 255.382
R156 a_1647_564.n0 a_1647_564.t7 243.296
R157 a_1647_564.n4 a_1647_564.n2 185.915
R158 a_1647_564.n3 a_1647_564.t5 184.712
R159 a_1647_564.n5 a_1647_564.n4 172.202
R160 a_1647_564.n1 a_1647_564.n0 147.814
R161 a_1647_564.n2 a_1647_564.n1 138.173
R162 a_1647_564.n5 a_1647_564.t3 136.357
R163 a_1647_564.n2 a_1647_564.t10 130.829
R164 a_1647_564.n1 a_1647_564.t9 96.4005
R165 a_1647_564.n0 a_1647_564.t8 96.4005
R166 a_1647_564.n3 a_1647_564.t6 94.7384
R167 a_1647_564.n4 a_1647_564.n3 84.766
R168 a_1647_564.t1 a_1647_564.n8 43.3874
R169 a_1647_564.n8 a_1647_564.t2 32.8338
R170 a_1647_564.n7 a_1647_564.n6 10.087
R171 a_1647_564.n6 a_1647_564.n5 0.558192
R172 a_633_564.n4 a_633_564.t1 375.014
R173 a_633_564.n5 a_633_564.n4 326.916
R174 a_633_564.n1 a_633_564.t5 271.313
R175 a_633_564.n3 a_633_564.t0 248.22
R176 a_633_564.n0 a_633_564.t6 233.655
R177 a_633_564.n2 a_633_564.n1 171.692
R178 a_633_564.n2 a_633_564.t3 165.317
R179 a_633_564.n0 a_633_564.t7 130.829
R180 a_633_564.n1 a_633_564.n0 94.1053
R181 a_633_564.t2 a_633_564.n5 43.3874
R182 a_633_564.n5 a_633_564.t4 32.8338
R183 a_633_564.n4 a_633_564.n3 5.58704
R184 a_633_564.n3 a_633_564.n2 5.05819
R185 a_1049_519.n3 a_1049_519.n2 312.567
R186 a_1049_519.n1 a_1049_519.t3 266.932
R187 a_1049_519.n0 a_1049_519.t5 244.903
R188 a_1049_519.n2 a_1049_519.n1 165.938
R189 a_1049_519.n2 a_1049_519.t0 132.749
R190 a_1049_519.n0 a_1049_519.t4 130.829
R191 a_1049_519.n1 a_1049_519.n0 89.7234
R192 a_1049_519.n3 a_1049_519.t1 42.2148
R193 a_1049_519.t2 a_1049_519.n3 32.8338
R194 a_204_564.n3 a_204_564.t7 338.092
R195 a_204_564.n2 a_204_564.t6 308.56
R196 a_204_564.n7 a_204_564.n6 307.58
R197 a_204_564.n8 a_204_564.n7 307.072
R198 a_204_564.n1 a_204_564.t8 269.921
R199 a_204_564.n4 a_204_564.n2 181.565
R200 a_204_564.n3 a_204_564.t10 175.22
R201 a_204_564.n4 a_204_564.n3 161.3
R202 a_204_564.n1 a_204_564.t9 144.601
R203 a_204_564.n5 a_204_564.n0 112.951
R204 a_204_564.n2 a_204_564.n1 102.401
R205 a_204_564.n6 a_204_564.t2 42.2148
R206 a_204_564.n6 a_204_564.t3 42.2148
R207 a_204_564.n8 a_204_564.t4 32.8338
R208 a_204_564.t5 a_204_564.n8 32.8338
R209 a_204_564.n0 a_204_564.t0 20.0005
R210 a_204_564.n0 a_204_564.t1 20.0005
R211 a_204_564.n5 a_204_564.n4 5.47165
R212 a_204_564.n7 a_204_564.n5 5.188
C8 Q GND 0.88461f
C9 D GND 0.96812f
C10 QB GND 0.91877f
C11 CLK GND 2.08953f
C12 VDD GND 5.70445f
C13 a_204_564.t4 GND 0.02884f ; **FLOATING
C14 a_204_564.t1 GND 0.02884f ; **FLOATING
C15 a_204_564.t0 GND 0.02884f ; **FLOATING
C16 a_204_564.n0 GND 0.08159f ; **FLOATING
C17 a_204_564.t8 GND 0.10004f ; **FLOATING
C18 a_204_564.t9 GND 0.0778f ; **FLOATING
C19 a_204_564.n1 GND 0.08634f ; **FLOATING
C20 a_204_564.t6 GND 0.17909f ; **FLOATING
C21 a_204_564.n2 GND 0.1704f ; **FLOATING
C22 a_204_564.t10 GND 0.16668f ; **FLOATING
C23 a_204_564.t7 GND 0.11376f ; **FLOATING
C24 a_204_564.n3 GND 0.14199f ; **FLOATING
C25 a_204_564.n4 GND 1.03628f ; **FLOATING
C26 a_204_564.n5 GND 0.63867f ; **FLOATING
C27 a_204_564.t3 GND 0.03707f ; **FLOATING
C28 a_204_564.t2 GND 0.03707f ; **FLOATING
C29 a_204_564.n6 GND 0.07731f ; **FLOATING
C30 a_204_564.n7 GND 0.38375f ; **FLOATING
C31 a_204_564.n8 GND 0.06057f ; **FLOATING
C32 a_204_564.t5 GND 0.02884f ; **FLOATING
C33 a_1049_519.t1 GND 0.04332f ; **FLOATING
C34 a_1049_519.t0 GND 0.14249f ; **FLOATING
C35 a_1049_519.t5 GND 0.12777f ; **FLOATING
C36 a_1049_519.t4 GND 0.10049f ; **FLOATING
C37 a_1049_519.n0 GND 0.10604f ; **FLOATING
C38 a_1049_519.t3 GND 0.20269f ; **FLOATING
C39 a_1049_519.n1 GND 0.13707f ; **FLOATING
C40 a_1049_519.n2 GND 1.09119f ; **FLOATING
C41 a_1049_519.n3 GND 0.0856f ; **FLOATING
C42 a_1049_519.t2 GND 0.0337f ; **FLOATING
C43 a_633_564.t4 GND 0.03566f ; **FLOATING
C44 a_633_564.t1 GND 0.16863f ; **FLOATING
C45 a_633_564.t0 GND 0.06869f ; **FLOATING
C46 a_633_564.t6 GND 0.13291f ; **FLOATING
C47 a_633_564.t7 GND 0.10633f ; **FLOATING
C48 a_633_564.n0 GND 0.11189f ; **FLOATING
C49 a_633_564.t5 GND 0.21567f ; **FLOATING
C50 a_633_564.n1 GND 0.1545f ; **FLOATING
C51 a_633_564.t3 GND 0.18346f ; **FLOATING
C52 a_633_564.n2 GND 1.10776f ; **FLOATING
C53 a_633_564.n3 GND 0.608f ; **FLOATING
C54 a_633_564.n4 GND 0.45655f ; **FLOATING
C55 a_633_564.n5 GND 0.09023f ; **FLOATING
C56 a_633_564.t2 GND 0.04712f ; **FLOATING
C57 a_1647_564.t2 GND 0.02493f ; **FLOATING
C58 a_1647_564.t4 GND 0.11501f ; **FLOATING
C59 a_1647_564.t9 GND 0.06768f ; **FLOATING
C60 a_1647_564.t8 GND 0.06768f ; **FLOATING
C61 a_1647_564.t7 GND 0.09458f ; **FLOATING
C62 a_1647_564.n0 GND 0.07854f ; **FLOATING
C63 a_1647_564.n1 GND 0.05766f ; **FLOATING
C64 a_1647_564.t10 GND 0.07436f ; **FLOATING
C65 a_1647_564.n2 GND 0.07597f ; **FLOATING
C66 a_1647_564.t5 GND 0.12859f ; **FLOATING
C67 a_1647_564.t6 GND 0.10268f ; **FLOATING
C68 a_1647_564.n3 GND 0.0926f ; **FLOATING
C69 a_1647_564.n4 GND 0.08374f ; **FLOATING
C70 a_1647_564.t3 GND 0.11139f ; **FLOATING
C71 a_1647_564.n5 GND 0.67564f ; **FLOATING
C72 a_1647_564.t0 GND 0.04853f ; **FLOATING
C73 a_1647_564.n6 GND 0.26894f ; **FLOATING
C74 a_1647_564.n7 GND 0.43934f ; **FLOATING
C75 a_1647_564.n8 GND 0.06049f ; **FLOATING
C76 a_1647_564.t1 GND 0.03295f ; **FLOATING
C77 a_633_84.t3 GND 0.04457f ; **FLOATING
C78 a_633_84.t6 GND 0.04939f ; **FLOATING
C79 a_633_84.n0 GND 0.10216f ; **FLOATING
C80 a_633_84.t4 GND 0.18649f ; **FLOATING
C81 a_633_84.t0 GND 0.12923f ; **FLOATING
C82 a_633_84.t5 GND 0.07019f ; **FLOATING
C83 a_633_84.n1 GND 0.68611f ; **FLOATING
C84 a_633_84.n2 GND 0.95092f ; **FLOATING
C85 a_633_84.t2 GND 0.04216f ; **FLOATING
C86 a_633_84.t7 GND 0.03373f ; **FLOATING
C87 a_633_84.n3 GND 0.0825f ; **FLOATING
C88 a_633_84.n4 GND 0.4641f ; **FLOATING
C89 a_633_84.n5 GND 0.71604f ; **FLOATING
C90 a_633_84.t1 GND 0.14978f ; **FLOATING
C91 VDD.t15 GND 0.02286f ; **FLOATING
C92 VDD.t3 GND 0.00716f ; **FLOATING
C93 VDD.t1 GND 0.00696f ; **FLOATING
C94 VDD.n0 GND 0.01597f ; **FLOATING
C95 VDD.t7 GND 0.00557f ; **FLOATING
C96 VDD.t5 GND 0.00716f ; **FLOATING
C97 VDD.n1 GND 0.01458f ; **FLOATING
C98 VDD.t13 GND 0.02545f ; **FLOATING
C99 VDD.t9 GND 0.00557f ; **FLOATING
C100 VDD.t11 GND 0.00716f ; **FLOATING
C101 VDD.n2 GND 0.01458f ; **FLOATING
C102 VDD.t19 GND 0.0271f ; **FLOATING
C103 VDD.n3 GND 0.09115f ; **FLOATING
C104 VDD.n4 GND 0.05256f ; **FLOATING
C105 VDD.n5 GND 0.05031f ; **FLOATING
C106 VDD.n6 GND 0.07889f ; **FLOATING
C107 VDD.t18 GND 0.28247f ; **FLOATING
C108 VDD.t8 GND 0.10671f ; **FLOATING
C109 VDD.t10 GND 0.11508f ; **FLOATING
C110 VDD.t12 GND 0.17367f ; **FLOATING
C111 VDD.t6 GND 0.16949f ; **FLOATING
C112 VDD.t4 GND 0.11508f ; **FLOATING
C113 VDD.t2 GND 0.11874f ; **FLOATING
C114 VDD.t0 GND 0.11979f ; **FLOATING
C115 VDD.t35 GND 0.12136f ; **FLOATING
C116 VDD.t24 GND 0.12136f ; **FLOATING
C117 VDD.t36 GND 0.15065f ; **FLOATING
C118 VDD.t25 GND 0.29921f ; **FLOATING
C119 VDD.t29 GND 0.11508f ; **FLOATING
C120 VDD.t31 GND 0.10671f ; **FLOATING
C121 VDD.t27 GND 0.16687f ; **FLOATING
C122 VDD.t33 GND 0.17628f ; **FLOATING
C123 VDD.t34 GND 0.12136f ; **FLOATING
C124 VDD.t37 GND 0.12136f ; **FLOATING
C125 VDD.t22 GND 0.11979f ; **FLOATING
C126 VDD.t20 GND 0.17733f ; **FLOATING
C127 VDD.t16 GND 0.17367f ; **FLOATING
C128 VDD.t14 GND 0.08108f ; **FLOATING
C129 VDD.n7 GND 0.32538f ; **FLOATING
C130 VDD.t17 GND 0.02545f ; **FLOATING
C131 VDD.t21 GND 0.00716f ; **FLOATING
C132 VDD.t23 GND 0.00696f ; **FLOATING
C133 VDD.n8 GND 0.01597f ; **FLOATING
C134 VDD.t28 GND 0.02286f ; **FLOATING
C135 VDD.t32 GND 0.00557f ; **FLOATING
C136 VDD.t30 GND 0.00716f ; **FLOATING
C137 VDD.n9 GND 0.01458f ; **FLOATING
C138 VDD.t26 GND 0.03052f ; **FLOATING
C139 VDD.n10 GND 0.09342f ; **FLOATING
C140 VDD.n11 GND 0.07805f ; **FLOATING
C141 VDD.n12 GND 0.07874f ; **FLOATING
C142 VDD.n13 GND 0.05256f ; **FLOATING
C143 VDD.n14 GND 0.76854f ; **FLOATING
C144 CLK.t4 GND 0.19176f ; **FLOATING
C145 CLK.t0 GND 0.09535f ; **FLOATING
C146 CLK.n0 GND 0.16343f ; **FLOATING
C147 CLK.t5 GND 0.10008f ; **FLOATING
C148 CLK.t6 GND 0.07784f ; **FLOATING
C149 CLK.n1 GND 0.10453f ; **FLOATING
C150 CLK.t1 GND 0.1518f ; **FLOATING
C151 CLK.n2 GND 0.12852f ; **FLOATING
C152 CLK.t9 GND 0.0783f ; **FLOATING
C153 CLK.t8 GND 0.0783f ; **FLOATING
C154 CLK.t7 GND 0.10943f ; **FLOATING
C155 CLK.n3 GND 0.09087f ; **FLOATING
C156 CLK.n4 GND 0.06672f ; **FLOATING
C157 CLK.t10 GND 0.08603f ; **FLOATING
C158 CLK.n5 GND 0.08789f ; **FLOATING
C159 CLK.t2 GND 0.14877f ; **FLOATING
C160 CLK.t3 GND 0.1188f ; **FLOATING
C161 CLK.n6 GND 0.10714f ; **FLOATING
C162 CLK.n7 GND 0.08474f ; **FLOATING
C163 CLK.n8 GND 0.50741f ; **FLOATING
C164 QB.t4 GND 0.01884f ; **FLOATING
C165 QB.t1 GND 0.01884f ; **FLOATING
C166 QB.n0 GND 0.03975f ; **FLOATING
C167 QB.t2 GND 0.02422f ; **FLOATING
C168 QB.t3 GND 0.02422f ; **FLOATING
C169 QB.n1 GND 0.05034f ; **FLOATING
C170 QB.n2 GND 0.21164f ; **FLOATING
C171 QB.t5 GND 0.01884f ; **FLOATING
C172 QB.t0 GND 0.01884f ; **FLOATING
C173 QB.n3 GND 0.04667f ; **FLOATING
C174 QB.n4 GND 0.27858f ; **FLOATING
C175 QB.t11 GND 0.07144f ; **FLOATING
C176 QB.t9 GND 0.05113f ; **FLOATING
C177 QB.t8 GND 0.0728f ; **FLOATING
C178 QB.n5 GND 0.05886f ; **FLOATING
C179 QB.t10 GND 0.05618f ; **FLOATING
C180 QB.n6 GND 0.06996f ; **FLOATING
C181 QB.t6 GND 0.09715f ; **FLOATING
C182 QB.t7 GND 0.07758f ; **FLOATING
C183 QB.n7 GND 0.08273f ; **FLOATING
C184 QB.n8 GND 0.05567f ; **FLOATING
C185 D.t2 GND 0.20377f ; **FLOATING
C186 D.t1 GND 0.04937f ; **FLOATING
C187 D.t0 GND 0.05471f ; **FLOATING
C188 D.n0 GND 0.10787f ; **FLOATING
C189 Q.t4 GND 0.10798f ; **FLOATING
C190 Q.t6 GND 0.03583f ; **FLOATING
C191 Q.t0 GND 0.03583f ; **FLOATING
C192 Q.n0 GND 0.07447f ; **FLOATING
C193 Q.n1 GND 0.36449f ; **FLOATING
C194 Q.t1 GND 0.03484f ; **FLOATING
C195 Q.t5 GND 0.02787f ; **FLOATING
C196 Q.n2 GND 0.06551f ; **FLOATING
C197 Q.n3 GND 0.17972f ; **FLOATING
C198 Q.t3 GND 0.02787f ; **FLOATING
C199 Q.t2 GND 0.02787f ; **FLOATING
C200 Q.n4 GND 0.08f ; **FLOATING
C201 Q.n5 GND 0.57225f ; **FLOATING
C202 Q.t7 GND 0.05958f ; **FLOATING
.ends
